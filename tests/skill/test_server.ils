;;; Copyright (c) 2025-2026 Bai Junyan and contributors.
;;; SPDX-License-Identifier: LGPL-3.0-or-later
;;; test_server.ils - Unit tests for python_server.ils using qtest

(qcover::load (strcat (qub::scriptDir) "/../../allegrobridge/_kernel/server/python_server.ils"))

(defun __pyTestWriteLines (fileName lines)
  (let ((port (outfile fileName)))
    (unless port (error "test_server: cannot create temporary file %s" fileName))
    (unwindProtect
      (foreach line lines (fprintf port "%s\n" line))
      (close port)))
  t)

(defun __pyTestBindGlobals (values)
  (let ((names nil) (snapshots nil) name)
    (foreach value values
      (setq name (gensym "__py_test_global_"))
      (setq snapshots
        (cons
          (list name
                (if (boundp name (theEnvironment))
                    (symeval name (theEnvironment))
                    'unbound))
          snapshots))
      (set name value)
      (setq names (cons name names)))
    (list (reverse names) (reverse snapshots))))

(defun __pyTestRestoreGlobals (snapshots)
  (foreach snapshot snapshots set(car(snapshot) cadr(snapshot)))
  t)

(defun __pyTestLegacySlots ()
  '(__pyCaptureWarnings __pyListToPython __pyOnData __pyOnDataScript
    __pyOnError __pyOnFinish __pyOnFinishScript __pyPropertyListToPython
    __pySaveToVariableAndReturn __pySkillToPython __pySpawnServer
    __pyStableRemoteVariable __pyTableToPython __pyVectorToPython __pyWriteFrame))

(defun __pyTestLegacyProperties ()
  '((pyStartServer ipc) (pyStartServer id) (pyStartServer logLevel)
    (pyStartServer singleMode) (pyStartServer timeout) (pyStartServer python)
    (pyStartServer forceTcp) (pyStartServer restartPending)
    (pyStartServer requestIpc) (pyStartServer receiveBuffer) (pyStartServer state)
    (pyStartServer moduleFolder) (pyStartServer logName)
    (pyRunScript logName) (pyShowLog logName) (pyReloadServer filename)
    (__pyWriteFrame STX) (__pyWriteFrame NAK) (__pyWriteFrame RST)
    (__pyWriteFrame ESC) (__pyWriteFrame RS) (__pyWriteFrame ESCPattern)
    (__pyWriteFrame RSPattern)))

(defun __pyTestSeedLegacySurface ()
  (foreach name (__pyTestLegacySlots)
    (putd name (lambda (@rest _args) 'legacy)))
  (foreach property (__pyTestLegacyProperties)
    (putprop (car property) 'legacy (cadr property)))
  (putprop 'pyStartServer 'keep 'userProperty)
  t)

(defun __pyTestClearLegacySurface ()
  (foreach name (__pyTestLegacySlots) (putd name nil))
  (foreach property (__pyTestLegacyProperties)
    (remprop (car property) (cadr property)))
  (remprop 'pyStartServer 'userProperty)
  t)

(defun __pyTestLegacySurfaceGone ()
  (let ((gone t))
    (foreach name (__pyTestLegacySlots)
      (when (not (null (getd name))) (setq gone nil)))
    (foreach property (__pyTestLegacyProperties)
      (when (not (null (get (car property) (cadr property)))) (setq gone nil)))
    gone))

(defun __pyTestPublicSurfacePresent ()
  (let ((present t))
    (foreach name '(pyStartServer pyKillServer pyRestartServer pyReloadScript pyShowLog pyRunScript
                    __pyIpcBeginProcess __pyIpcKillProcess __pyIpcWriteProcess __pyIpcWait)
      (when (null (getd name)) (setq present nil)))
    present))

(defun __pyTestWithFakeIpc (handles waitResult thunk)
  (let ((originalBegin (getd '__pyIpcBeginProcess))
        (originalWrite (getd '__pyIpcWriteProcess))
        (originalKill (getd '__pyIpcKillProcess))
        (originalWait (getd '__pyIpcWait))
        (originalPythonPath (getShellEnvVar "PYTHONPATH"))
        accessors)
    handles["begins"] = nil
    handles["writes"] = nil
    handles["kills"] = nil
    handles["waits"] = nil
    accessors = list(nil 'begins (lambda () handles["begins"])
                     'writes (lambda () handles["writes"])
                     'kills (lambda () handles["kills"])
                     'waits (lambda () handles["waits"]))
    unwindProtect(
      progn(
        putd('__pyIpcBeginProcess
          (lambda (command host dataHandler errorHandler postHandler logFile)
            let((handle)
              handle = if(handles["handle"] then handles["handle"]
                          else gensym("__py_test_child_"))
              handles["begins"] = append(handles["begins"]
                list(list(handle command host dataHandler errorHandler postHandler logFile
                          (getShellEnvVar "PYTHONPATH"))))
              handle)))
        putd('__pyIpcWriteProcess
          (lambda (process data)
            handles["writes"] = append(handles["writes"] list(list(process data))) t))
        putd('__pyIpcKillProcess
          (lambda (process)
            handles["kills"] = append(handles["kills"] list(process)) t))
        putd('__pyIpcWait
          (lambda (process)
            handles["waits"] = append(handles["waits"] list(process)) waitResult))
        funcall(thunk accessors))
      progn(
        when(handles["begins"]
          foreach(begin handles["begins"]
            when(nth(5 begin)
              funcall(nth(5 begin) nth(0 begin) 0))))
        putd('__pyIpcBeginProcess originalBegin)
        putd('__pyIpcWriteProcess originalWrite)
        putd('__pyIpcKillProcess originalKill)
        putd('__pyIpcWait originalWait)
        if(originalPythonPath then setShellEnvVar("PYTHONPATH" originalPythonPath)
          else unsetShellEnvVar("PYTHONPATH"))
        t))))

(qtest::runSuites
  (qtest::TestSuite ((actual nil) (handles (makeTable "s1" nil)))
    (qtest::TestCase test_serialize_boolean
      (setq actual (__pyTestWithFakeIpc handles nil (lambda (a)
        let((b cb p) p=pyRunScript("x") b=car(funcall(nth(2 a))) cb=nth(3 b)
          funcall(cb p "t\nnil\n") mapcar('cadr funcall(nth(4 a)))))))
      (qtest::assertEqual '("success True\n" "success None\n") actual))
    (qtest::TestCase test_serialize_numbers
      (setq actual (__pyTestWithFakeIpc handles nil (lambda (a)
        let((b cb p) p=pyRunScript("x") b=car(funcall(nth(2 a))) cb=nth(3 b)
          funcall(cb p "42\n-10\n3.14\n") mapcar('cadr funcall(nth(4 a)))))))
      (qtest::assertEqual '("success 42\n" "success -10\n" "success 3.14\n") actual))
    (qtest::TestCase test_serialize_string
      (setq actual (__pyTestWithFakeIpc handles nil (lambda (a)
        let((b cb p) p=pyRunScript("x") b=car(funcall(nth(2 a))) cb=nth(3 b)
          funcall(cb p "\"hello world\"\n\"\"\n") mapcar('cadr funcall(nth(4 a)))))))
      (qtest::assertEqual '("success \"hello world\"\n" "success \"\"\n") actual))
    (qtest::TestCase test_serialize_symbol
      (setq actual (__pyTestWithFakeIpc handles nil (lambda (a)
        let((b cb p) p=pyRunScript("x") b=car(funcall(nth(2 a))) cb=nth(3 b)
          funcall(cb p "'my_symbol\n") mapcar('cadr funcall(nth(4 a)))))))
      (qtest::assertEqual '("success Symbol('my_symbol')\n") actual)))

  (qtest::TestSuite ((actual nil) (handles (makeTable "s2" nil)))
    (qtest::TestCase test_serialize_list
      (setq actual (__pyTestWithFakeIpc handles nil (lambda (a)
        let((b cb p) p=pyRunScript("x") b=car(funcall(nth(2 a))) cb=nth(3 b)
          funcall(cb p "(list)\n(list 1 2 3)\n(list \"a\" t nil)\n(list 1 (list 2 3))\n")
          mapcar('cadr funcall(nth(4 a)))))))
      (qtest::assertEqual '("success None\n" "success [1,2,3]\n" "success [\"a\",True,None]\n" "success [1,[2,3]]\n") actual))
    (qtest::TestCase test_serialize_disembodied_property_list
      (setq actual (__pyTestWithFakeIpc handles nil (lambda (a)
        let((b cb p) p=pyRunScript("x") b=car(funcall(nth(2 a))) cb=nth(3 b)
          funcall(cb p "(list nil 'a 1 'b 2)\n(list nil 'name \"skillbridge\")\n")
          mapcar('cadr funcall(nth(4 a)))))))
      (qtest::assertEqual '("success {'a':1,'b':2}\n" "success {'name':\"skillbridge\"}\n") actual)))

  (qtest::TestSuite ((actual nil) (handles (makeTable "s3" nil)))
    (qtest::TestCase test_serialize_table
      (setq actual (__pyTestWithFakeIpc handles nil (lambda (a)
        let((b cb p) p=pyRunScript("x") b=car(funcall(nth(2 a))) cb=nth(3 b)
          funcall(cb p "(makeTable \"x\" nil)\n") car(funcall(nth(4 a)))))))
      (qtest::assertTrue (qub::startsWith (cadr actual) "success Table(\"__py_table_")))
    (qtest::TestCase test_serialize_vector
      (setq actual (__pyTestWithFakeIpc handles nil (lambda (a)
        let((b cb p) p=pyRunScript("x") b=car(funcall(nth(2 a))) cb=nth(3 b)
          funcall(cb p "(makeVector 2 nil)\n") car(funcall(nth(4 a)))))))
      (qtest::assertTrue (qub::startsWith (cadr actual) "success Vector(\"__py_vector_"))))

  (qtest::TestSuite ((actual nil) (handles (makeTable "initial" nil)))
    (qtest::TestCase test_server_initial_state
      (setq actual (__pyTestWithFakeIpc handles nil (lambda (_accessors)
        progn(pyStartServer
              list((not (null (getd 'pyKillServer)))
                   (not (null (getd 'pyRestartServer)))
                   (not (null (getd 'pyReloadScript)))
                   (not (null (getd 'pyShowLog)))
                   (not (null (getd 'pyRunScript))))))))
      (qtest::assertEqual '(t t t t t t) actual)))

  (qtest::TestSuite ((actual nil) (handles (makeTable "s5" nil)))
    (qtest::TestCase test_spawn_server_builds_all_command_variants
      (setq actual (__pyTestWithFakeIpc handles nil (lambda (a)
        let((bs p second)
          pyStartServer(?id "workspace" ?logLevel "DEBUG" ?python "python-test")
          bs=car(funcall(nth(2 a))) p=nth(5 bs) funcall(p nth(0 bs) 0)
          pyStartServer(?singleMode t ?forceTcp t ?timeout 2.5)
          second=cadr(funcall(nth(2 a))) funcall(nth(5 second) nth(0 second) 0)
          list(length(funcall(nth(2 a)))
            type(nth(3 bs)) type(nth(4 bs)) type(nth(5 bs))
            (type (nth 3 (cadr (funcall (nth 2 a)))))
            (type (nth 4 (cadr (funcall (nth 2 a)))))
            (type (nth 5 (cadr (funcall (nth 2 a))))))))))
      (qtest::assertEqual '(2 funobj funobj funobj funobj funobj funobj funobj) actual))
    (qtest::TestCase test_spawn_server_passes_string_id_unquoted
      (setq actual (__pyTestWithFakeIpc handles nil (lambda (a)
        let((b) pyStartServer(?id "7777")
          b=car(funcall(nth(2 a))) nth(1 b)))))
      (qtest::assertEqual
        "\"python\" -m allegrobridge._kernel.server.python_server 7777 INFO"
        actual))
    (qtest::TestCase test_spawn_server_temporarily_sets_and_restores_pythonpath
      (setq actual (__pyTestWithFakeIpc handles nil (lambda (a)
        let((old) old=getShellEnvVar("PYTHONPATH") unsetShellEnvVar("PYTHONPATH")
          pyStartServer() setShellEnvVar("PYTHONPATH" "qtest-original-path")
          pyStartServer() getShellEnvVar("PYTHONPATH")))))
      (qtest::assertEqual "qtest-original-path" actual))
    (qtest::TestCase test_module_folder_is_package_parent
      (setq actual (__pyTestWithFakeIpc handles nil
        (lambda (a) pyRunScript("x") index(nth(6 (car(funcall(nth(2 a))))) "allegrobridge"))))
      (qtest::assertTrue actual))
    (qtest::TestCase test_kill_and_restart_lifecycle
      (setq actual (__pyTestWithFakeIpc handles nil (lambda (a)
        let((b)
          pyStartServer()
          b=car(funcall(nth(2 a))) pyKillServer()
          funcall(nth(5 b) nth(0 b) 0) pyRestartServer()
          list(length(funcall(nth(6 a))) length(funcall(nth(2 a)))
               length(funcall(nth(8 a))))))))
      (qtest::assertEqual '(1 2 0) actual)))

  (qtest::TestSuite ((actual nil))
    (qtest::TestCase test_show_log_handles_invalid_missing_and_ring_buffer_files
      (setq actual
        (let ((logFile (strcat (or (getShellEnvVar "ALLEGROBRIDGE_LOG_DIRECTORY") ".")
                               "/allegrobridge_skill.log"))
              (capture (outstring))
              oldOutput)
          (unwindProtect
            (progn
              (__pyTestWriteLines logFile '("one" "two" "three"))
              (setq oldOutput (symeval 'poport))
              (set 'poport capture)
              (list (pyShowLog 0) (pyShowLog 2) (getOutstring capture)
                    (pyShowLog -1)))
            (progn
              (set 'poport oldOutput)
              (close capture)
              (deleteFile logFile)))))
      (qtest::assertEqual '(nil t "two\nthree\n" nil) actual)))

  (qtest::TestSuite ((actual nil) (handles (makeTable "s7" nil)))
    (qtest::TestCase test_write_frame_escapes_payload_delimiters
      (setq actual
        (__pyTestWithFakeIpc handles nil (lambda (a)
          let((b c p) pyStartServer() b=car(funcall(nth(2 a)))
            p=nth(0 b) c=nth(3 b)
            funcall(c p "concat(\"left\" strcat(intToChar(27)) \"middle\" strcat(intToChar(30)) \"right\")\n")
            cadr(car(funcall(nth(4 a))))))))
      (qtest::assertEqual
        (strcat (intToChar 2)
                      "left"
                      (intToChar 27)
                      (intToChar 27)
                      "middle"
                      (intToChar 27)
                      (intToChar 30)
                      "right"
                      (intToChar 30))
        actual))
    (qtest::TestCase test_on_data_buffers_partial_and_multiple_lines
      (setq actual (__pyTestWithFakeIpc handles nil (lambda (a)
        let((b c p) pyStartServer() b=car(funcall(nth(2 a))) p=nth(0 b) c=nth(3 b)
          funcall(c p "plus(1 ") funcall(c 'stale "99)\n") funcall(c p "2)\r\n\r\n\nplus(3 4)\nplus(5 ")
          funcall(c p "6)\n") list(mapcar('cadr funcall(nth(4 a))) "")))))
      (qtest::assertEqual
        (list
          (list (strcat (intToChar 2) "3" (intToChar 30))
                (strcat (intToChar 2) "7" (intToChar 30))
                (strcat (intToChar 2) "11" (intToChar 30)))
          "")
        actual))
    (qtest::TestCase test_on_data_frames_crlf_split_and_empty_chunks
      (setq actual (__pyTestWithFakeIpc handles nil (lambda (a)
        let((b c p) pyStartServer() b=car(funcall(nth(2 a))) p=nth(0 b) c=nth(3 b)
          funcall(c p "plus(1 2)\r") funcall(c p "\n") funcall(c p "") funcall(c p "\n") funcall(c p "plus(3 4)\n")
          list(mapcar('cadr funcall(nth(4 a))) "")))))
      (qtest::assertEqual
        (list
          (list (strcat (intToChar 2) "3" (intToChar 30))
                (strcat (intToChar 2) "7" (intToChar 30)))
          "")
        actual))
    (qtest::TestCase test_receive_buffer_follows_process_lifecycle
      (setq actual (__pyTestWithFakeIpc handles nil (lambda (a)
        let((b p post) pyStartServer() b=car(funcall(nth(2 a))) p=nth(0 b) post=nth(5 b)
          funcall(post 'stale 0) funcall(post p 0)
          list(length(funcall(nth(6 a))) length(funcall(nth(2 a))))))))
      (qtest::assertEqual '(0 1) actual))
    (qtest::TestCase test_on_data_writes_error_unbound_warning_success_and_restart
      (setq actual (__pyTestWithFakeIpc handles nil (lambda (a)
        let((b c p old sentinel same restored writes)
          pyStartServer() b=car(funcall(nth(2 a))) p=nth(0 b) c=nth(3 b)
          old=symeval('woport) sentinel=outstring()
          unwindProtect(
            progn(
              set('woport sentinel)
              funcall(c p "error(\"qtest boom\")\n")
              funcall(c p "makeTable(\"u\")[\"x\"]\n")
              funcall(c p "plus(1 2)\n")
              funcall(c p "progn(warn(\"qtest warning\") 7)\n")
              pyRestartServer()
              funcall(c p "plus(2 3)\n")
              same=eq(symeval('woport) sentinel)
              writes=mapcar('cadr funcall(nth(4 a))))
            progn(
              set('woport old)
              restored=eq(symeval('woport) old)
              close(sentinel)))
          list(writes same restored)))))
      (qtest::assertEqual 5 (length (car actual)))
      (qtest::assertTrue (cadr actual))
      (qtest::assertTrue (caddr actual)))
    (qtest::TestCase test_on_data_treats_inner_errset_as_success
      (setq actual (__pyTestWithFakeIpc handles nil (lambda (a)
        let((b c p s old same restored writes)
          pyStartServer() b=car(funcall(nth(2 a))) p=nth(0 b) c=nth(3 b)
          old=symeval('woport) s=outstring()
          unwindProtect(
            progn(
              set('woport s)
              funcall(c p "errset(error(\"qtest inner boom\"))\n")
              funcall(c p "error(\"qtest outer boom\")\n")
              same=eq(symeval('woport) s)
              writes=mapcar('cadr funcall(nth(4 a))))
            progn(
              set('woport old)
              restored=eq(symeval('woport) old)
              close(s)))
          list(writes same restored)))))
      (qtest::assertTrue (qub::startsWith (cadr (car actual)) (strcat (intToChar 21))))
      (qtest::assertTrue (null (index (cadr (car actual)) "qtest inner boom")))
      (qtest::assertTrue (cadr actual))
      (qtest::assertTrue (caddr actual)))
    (qtest::TestCase test_on_data_script_treats_inner_errset_as_success
      (setq actual (__pyTestWithFakeIpc handles nil (lambda (a)
        let((b c p s old same restored writes)
          p=pyRunScript("x") b=car(funcall(nth(2 a))) c=nth(3 b)
          old=symeval('woport) s=outstring()
          unwindProtect(
            progn(
              set('woport s)
              funcall(c p "errset(error(\"qtest inner boom\"))\n")
              funcall(c p "error(\"qtest outer boom\")\n")
              same=eq(symeval('woport) s)
              writes=mapcar('cadr funcall(nth(4 a))))
            progn(
              set('woport old)
              restored=eq(symeval('woport) old)
              close(s)))
          list(writes same restored)))))
      (qtest::assertTrue (qub::startsWith (cadr (car actual)) "failure "))
      (qtest::assertTrue (null (index (cadr (car actual)) "qtest inner boom")))
      (qtest::assertTrue (cadr actual))
      (qtest::assertTrue (caddr actual)))
    (qtest::TestCase test_on_data_script_writes_newline_protocol
      (setq actual (__pyTestWithFakeIpc handles nil (lambda (a)
        let((b c p) p=pyRunScript("x") b=car(funcall(nth(2 a))) p=nth(0 b) c=nth(3 b)
          funcall(c p "plus(1 2)\nerror(\"qtest boom\")\n") funcall(c p "makeTable(\"u\")[\"x\"]\n")
          funcall(c p "progn(warn(\"qtest warning\") 7)\n") funcall(c p "plus(3 4)\n\nplus(5 6)\n") mapcar('cadr funcall(nth(4 a)))))))
      (qtest::assertEqual 6 (length actual)))
    (qtest::TestCase test_on_finish_ignores_stale_and_restarts_current_process
      (setq actual (__pyTestWithFakeIpc handles nil (lambda (a)
        let((b post p staleBegins) pyStartServer() b=car(funcall(nth(2 a))) p=nth(0 b) post=nth(5 b)
          pyRestartServer() funcall(post 'stale 1)
          staleBegins=length(funcall(nth(2 a))) funcall(post p 0)
          list(staleBegins length(funcall(nth(2 a))) length(funcall(nth(6 a))))))))
      (qtest::assertEqual '(1 2 1) actual)))

  (qtest::TestSuite ((actual nil))
    (qtest::TestCase test_remote_serialization_handles_regex_other_port_and_fallback
      (setq actual
        (let (port bindings names result)
          (setq port (outstring))
          (unwindProtect
            (progn
              (setq bindings
                (__pyTestBindGlobals
                  (list (pcreCompile "abc") (qtest:::makeResult 'Pass "" nil nil) port)))
              (setq names (car bindings))
              (setq result
                (__pyTestWithFakeIpc (makeTable "r1" nil) nil
                  (lambda (accessors)
                    (let (entry callback process)
                      (setq process (pyRunScript "x"))
                      (setq entry (car (funcall (nth 2 accessors))))
                      (setq callback (nth 3 entry))
                      (funcall callback process (strcat (symbolToString (nth 0 names)) "\n"))
                      (funcall callback process (strcat (symbolToString (nth 1 names)) "\n"))
                      (funcall callback process (strcat (symbolToString (nth 2 names)) "\n"))
                      (mapcar 'cadr (funcall (nth 4 accessors)))))))
              result)
            (progn
              (when bindings (__pyTestRestoreGlobals (cadr bindings)))
              (when port (close port))))))
      (qtest::assertEqual 3 (length actual)))
    (qtest::TestCase test_remote_serialization_reuses_variable_for_identical_object
      (setq actual
        (let (first second bindings names result)
          (setq first (pcreCompile "abc"))
          (setq second (pcreCompile "def"))
          (unwindProtect
            (progn
              (setq bindings (__pyTestBindGlobals (list first second)))
              (setq names (car bindings))
              (setq result
                (__pyTestWithFakeIpc (makeTable "r2" nil) nil
                  (lambda (accessors)
                    (let (entry callback process)
                      (setq process (pyRunScript "x"))
                      (setq entry (car (funcall (nth 2 accessors))))
                      (setq callback (nth 3 entry))
                      (funcall callback process (strcat (symbolToString (nth 0 names)) "\n"))
                      (funcall callback process (strcat (symbolToString (nth 0 names)) "\n"))
                      (funcall callback process (strcat (symbolToString (nth 1 names)) "\n"))
                      (mapcar 'cadr (funcall (nth 4 accessors)))))))
              (list result (equal (car result) (cadr result))))
            (when bindings (__pyTestRestoreGlobals (cadr bindings))))))
      (qtest::assertTrue (cadr actual))
      (qtest::assertTrue (null (equal (nth 0 (car actual)) (nth 2 (car actual))))))
    (qtest::TestCase test_remote_serialization_reuses_variable_for_identical_port
      (setq actual
        (let (port bindings name result)
          (setq port (outstring))
          (unwindProtect
            (progn
              (setq bindings (__pyTestBindGlobals (list port)))
              (setq name (car (car bindings)))
              (setq result
                (__pyTestWithFakeIpc (makeTable "r3" nil) nil
                  (lambda (accessors)
                    (let (entry callback process)
                      (setq process (pyRunScript "x"))
                      (setq entry (car (funcall (nth 2 accessors))))
                      (setq callback (nth 3 entry))
                      (funcall callback process (strcat (symbolToString name) "\n"))
                      (funcall callback process (strcat (symbolToString name) "\n"))
                      (mapcar 'cadr (funcall (nth 4 accessors)))))))
              result)
            (progn
              (when bindings (__pyTestRestoreGlobals (cadr bindings)))
              (when port (close port))))))
      (qtest::assertEqual (car actual) (cadr actual))))

  (qtest::TestSuite ((actual nil) (handles (makeTable "s9" nil)))
    (qtest::TestCase test_start_server_rejects_duplicate_and_forwards_configuration
      (setq actual (__pyTestWithFakeIpc handles nil (lambda (a)
        let((x y begins first post)
          x=pyStartServer()
          first=car(funcall(nth(2 a))) post=nth(5 first)
          y=pyStartServer(?id "configured")
          funcall(post nth(0 first) 0)
          y=pyStartServer(?id "configured" ?logLevel "DEBUG" ?singleMode t ?timeout 4.0 ?python "python-test" ?forceTcp t)
          begins=funcall(nth(2 a))
          list(x y length(begins) (nth 1 (cadr begins)))))
      (qtest::assertEqual '(t nil 2 "\"python-test\" -m allegrobridge._kernel.server.python_server configured DEBUG --single --force-tcp --timeout 4.0") actual))
    (qtest::TestCase test_run_script_inherits_server_python_and_restores_pythonpath
      (setq actual (__pyTestWithFakeIpc handles nil (lambda (a)
        let((old b) old=getShellEnvVar("PYTHONPATH") pyStartServer(?python "server-python-exe") pyRunScript("x") b=car(funcall(nth(2 a)))
          list(not(null(index(nth(1 b) "server-python-exe x"))) equal(getShellEnvVar("PYTHONPATH") old))))))
      (qtest::assertEqual '(t t) actual))
    (qtest::TestCase test_run_script_restores_preexisting_pythonpath
      (setq actual (__pyTestWithFakeIpc handles nil (lambda (a) setShellEnvVar("PYTHONPATH" "preexisting-pythonpath") pyRunScript("x") getShellEnvVar("PYTHONPATH"))))
      (qtest::assertEqual "preexisting-pythonpath" actual))
    (qtest::TestCase test_run_script_returns_process_or_waits
      (setq actual (__pyTestWithFakeIpc handles t (lambda (a)
        let((x y b first second) x=pyRunScript("x" ?python "python-test" ?args '("a" "b")) y=pyRunScript("x" ?block t) b=funcall(nth(2 a))
          first=car(b) second=cadr(b)
          list(not(null(x)) not(null(y)) length(b)
            type(nth(3 first)) type(nth(4 first)) type(nth(5 first))
            type(nth(3 second)) type(nth(4 second)) type(nth(5 second))
            null(eq(nth(3 first) nth(3 second))) null(eq(nth(5 first) nth(5 second)))
            length(funcall(nth(8 a))))))))
      (qtest::assertEqual '(t t 2 funobj funobj funobj funobj funobj funobj t t 1) actual))
    (qtest::TestCase test_run_script_buffers_fragmented_interleaved_children
      (setq actual
        (__pyTestWithFakeIpc handles nil
          (lambda (accessors)
            (let (begins processA processB callbackA callbackB)
              (pyRunScript "a")
              (pyRunScript "b")
              (setq begins (funcall (nth 2 accessors)))
              (setq processA (nth 0 (car begins)))
              (setq processB (nth 0 (cadr begins)))
              (setq callbackA (nth 3 (car begins)))
              (setq callbackB (nth 3 (cadr begins)))
              (funcall callbackA processA "0")
              (funcall callbackB processB "0")
              (funcall callbackA processA "3\n")
              (funcall callbackB processB "30\n")
              (mapcar 'cadr (funcall (nth 4 accessors)))))))
      (qtest::assertEqual '("success 3\n" "success 30\n") actual))
    (qtest::TestCase test_run_script_reused_id_drops_late_callbacks
      (setq actual
        (__pyTestWithFakeIpc handles nil
          (lambda (accessors)
            (let (begins process oldEntry newEntry oldCallback newCallback oldPost newPost)
              handles["handle"] = 'shared
              (setq process (pyRunScript "old"))
              (setq oldEntry (car (funcall (nth 2 accessors))))
              (setq oldCallback (nth 3 oldEntry))
              (setq oldPost (nth 5 oldEntry))
              (funcall oldCallback process "1")
              (funcall oldPost process 0)
              (pyRunScript "new")
              (setq begins (funcall (nth 2 accessors)))
              (setq newEntry (cadr begins))
              (setq newCallback (nth 3 newEntry))
              (setq newPost (nth 5 newEntry))
              (funcall oldCallback process "2\n")
              (funcall newCallback process "0")
              (funcall oldPost process 0)
              (funcall newCallback process "7\n")
              (funcall newPost process 0)
              (funcall newCallback process "18\n")
              (mapcar 'cadr (funcall (nth 4 accessors)))))))
      (qtest::assertEqual '("success 7\n") actual))
    (qtest::TestCase test_reload_rejects_old_callback_and_preserves_public_api
      (setq actual
        (let ((handlesForReload (makeTable "reload" nil))
              old
              oldData
              reloadIpc
              reloadBegins
              nested
              callables)
          handlesForReload["handle"] = 'reloadProcess
          (__pyTestWithFakeIpc handlesForReload nil
            (lambda (accessors)
              (pyStartServer)
              (setq old (car (funcall (nth 2 accessors))))
              (setq oldData (nth 3 old))
              (pyReloadScript)
              (setq reloadIpc (nth 0 (car (funcall (nth 2 accessors)))))
              (setq reloadBegins (length (funcall (nth 2 accessors))))
              (setq callables
                (list (not (null (getd 'pyStartServer)))
                      (not (null (getd 'pyKillServer)))
                      (not (null (getd 'pyRestartServer)))
                      (not (null (getd 'pyReloadScript)))
                      (not (null (getd 'pyShowLog)))
                      (not (null (getd 'pyRunScript)))))
              (setq nested
                (__pyTestWithFakeIpc handlesForReload nil
                  (lambda (newAccessors)
                    (let (entry data)
                      (pyStartServer)
                      (setq entry (car (funcall (nth 2 newAccessors))))
                      (setq data (nth 3 entry))
                      (funcall oldData 'reloadProcess "plus(1 2)\n")
                      (funcall data 'reloadProcess "plus(3 4)\n")
                      (mapcar 'cadr (funcall (nth 4 newAccessors)))))))
              (list nested reloadIpc reloadBegins callables)))))
      (qtest::assertEqual 1 (length (car actual)))
      (qtest::assertEqual
        (strcat (intToChar 2) "7" (intToChar 30))
        (car (car actual)))
      (qtest::assertEqual nil (cadr actual))
      (qtest::assertEqual 1 (caddr actual))
      (qtest::assertEqual '(t t t t t t) (cadddr actual)))

    (qtest::TestCase test_request_context_is_cleared_after_write_error
      (setq actual
        (__pyTestWithFakeIpc (makeTable "write-error" nil) nil
          (lambda (accessors)
            (let (entry callback process failed)
              (pyStartServer)
              (setq entry (car (funcall (nth 2 accessors))))
              (setq process (nth 0 entry))
              (setq callback (nth 3 entry))
              (putd '__pyIpcWriteProcess
                (lambda (_process _data) (error "qtest write boom")))
              (setq failed (null (errset (funcall callback process "plus(1 2)\n"))))
              (pyRestartServer)
              (list failed (length (funcall (nth 6 accessors))))))))
      (qtest::assertEqual '(t 1) actual)))

  (qtest::TestSuite ((actual nil))
    (qtest::TestCase test_fresh_load_removes_legacy_surface_and_keeps_user_property
      (setq actual
        (let ((moduleFile (strcat (qub::scriptDir)
                                  "/../../allegrobridge/_kernel/server/python_server.ils"))
              result)
          (__pyTestSeedLegacySurface)
          (load moduleFile)
          (setq result
            (list (__pyTestLegacySurfaceGone)
                  (__pyTestPublicSurfacePresent)
                  (equal (get 'pyStartServer 'userProperty) 'keep)))
          (__pyTestClearLegacySurface)
          result))
      (qtest::assertEqual '(t t t) actual)))

  (qtest::TestSuite ((actual nil) (handles (makeTable "hot-reload" nil)))
    (qtest::TestCase test_hot_reload_removes_legacy_surface_and_keeps_user_property
      (setq actual
        (__pyTestWithFakeIpc handles nil
          (lambda (_accessors)
            (__pyTestSeedLegacySurface)
            (pyStartServer)
            (pyReloadScript)
            (setq actual
              (list (__pyTestLegacySurfaceGone)
                    (__pyTestPublicSurfacePresent)
                    (equal (get 'pyStartServer 'userProperty) 'keep)))
            (__pyTestClearLegacySurface)
            actual)))
      (qtest::assertEqual '(t t t) actual)))

  (qtest::TestSuite ((actual nil))
    (qtest::TestCase test_real_ipc_callbacks_retain_lexical_data_after_return
      (setq actual
        (let (process data finished)
          (setq data "")
          (setq finished nil)
          (setq process
            (ipcBeginProcess
              "cmd /c echo lexical-data"
              ""
              (lambda (_id chunk) (setq data (strcat data chunk)))
              nil
              (lambda (_id status) (setq finished status))))
          (ipcWait process 1 10)
          (list (not (null process)) (index data "lexical-data") finished)))
      (qtest::assertTrue (car actual))
      (qtest::assertTrue (cadr actual))
      (qtest::assertEqual 0 (caddr actual)))))))
