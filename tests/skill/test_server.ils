;;; Copyright (c) 2025-2026 Bai Junyan and contributors.
;;; SPDX-License-Identifier: LGPL-3.0-or-later
;;; test_server.ils - Unit tests for python_server.ils using qtest

(qcover::load (strcat (qub::scriptDir) "/../../allegrobridge/_kernel/server/python_server.ils"))

(defun __pyTestWriteLines (fileName lines)
  (let ((port (outfile fileName)))
    (unless port (error "test_server: cannot create temporary file %s" fileName))
    (unwindProtect
      (foreach line lines (fprintf port "%s\n" line))
      (close port)))
  t)

(defun __pyTestBindGlobals (values)
  (let ((names nil) (snapshots nil) name)
    (foreach value values
      (setq name (gensym "__py_test_global_"))
      (setq snapshots
        (cons
          (list name
                (boundp name (theEnvironment))
                (when (boundp name (theEnvironment))
                  (symeval name (theEnvironment))))
          snapshots))
      (set name value)
      (setq names (cons name names)))
    (list (reverse names) (reverse snapshots))))

(defun __pyTestRestoreGlobals (snapshots)
  (foreach snapshot snapshots
    (if (cadr snapshot)
        (set (car snapshot) (caddr snapshot))
        (set (car snapshot) 'unbound)))
  t)

(defun __pyTestLegacySlots ()
  '(__pyCaptureWarnings __pyListToPython __pyOnData __pyOnDataScript
    __pyOnError __pyOnFinish __pyOnFinishScript __pyPropertyListToPython
    __pySaveToVariableAndReturn __pySkillToPython __pySpawnServer
    __pyStableRemoteVariable __pyTableToPython __pyVectorToPython __pyWriteFrame))

(defun __pyTestLegacyProperties ()
  '((pyStartServer ipc) (pyStartServer id) (pyStartServer logLevel)
    (pyStartServer singleMode) (pyStartServer timeout) (pyStartServer python)
    (pyStartServer forceTcp) (pyStartServer restartPending)
    (pyStartServer requestIpc) (pyStartServer receiveBuffer) (pyStartServer state)
    (pyStartServer moduleFolder) (pyStartServer logName)
    (pyRunScript logName) (pyShowLog logName) (pyReloadServer filename)
    (__pyStableRemoteVariable Registry)
    (__pyWriteFrame STX) (__pyWriteFrame NAK) (__pyWriteFrame RST)
    (__pyWriteFrame ESC) (__pyWriteFrame RS) (__pyWriteFrame ESCPattern)
    (__pyWriteFrame RSPattern)))

(defun __pyTestSurfaceSlots ()
  (append
    (__pyTestLegacySlots)
    '(pyStartServer pyKillServer pyRestartServer pyReloadScript pyShowLog pyRunScript
      __pyIpcBeginProcess __pyIpcKillProcess __pyIpcWriteProcess __pyIpcWait)))

(defun __pyTestPropertyPresentp (property properties)
  (if properties
      (if (eq property (car properties))
          t
          (__pyTestPropertyPresentp property (cddr properties)))
      nil))

(defun __pyTestSnapshotLegacySurface ()
  (let ((slots nil) (properties nil) property propertyList present)
    (foreach name (__pyTestSurfaceSlots)
      (setq slots (cons (list name (getd name)) slots)))
    (foreach pair (__pyTestLegacyProperties)
      (setq property (cadr pair))
      (setq propertyList (plist (car pair)))
      (setq present (__pyTestPropertyPresentp property propertyList))
      (setq properties
        (cons
          (list (car pair) property present
                (when present (get (car pair) property)))
          properties)))
    (list slots properties
          (__pyTestPropertyPresentp 'userProperty (plist 'pyStartServer))
          (get 'pyStartServer 'userProperty))))

(defun __pyTestRestoreLegacySurface (snapshot)
  (let (slot property)
    (foreach slot (car snapshot)
      (putd (car slot) (cadr slot)))
    (foreach property (cadr snapshot)
      (if (caddr property)
          (putprop (car property) (cadddr property) (cadr property))
          (remprop (car property) (cadr property))))
    (if (caddr snapshot)
        (putprop 'pyStartServer (cadddr snapshot) 'userProperty)
        (remprop 'pyStartServer 'userProperty))
    t))

(defun __pyTestSeedLegacySurface ()
  (foreach name (__pyTestLegacySlots)
    (putd name (lambda (@rest _args) 'legacy)))
  (foreach property (__pyTestLegacyProperties)
    (putprop (car property) 'legacy (cadr property)))
  (putprop 'pyStartServer 'keep 'userProperty)
  t)

(defun __pyTestClearLegacySurface ()
  (foreach name (__pyTestLegacySlots) (putd name nil))
  (foreach property (__pyTestLegacyProperties)
    (remprop (car property) (cadr property)))
  (remprop 'pyStartServer 'userProperty)
  t)

(defun __pyTestLegacySurfaceGone ()
  (let ((gone t) propertyList)
    (foreach name (__pyTestLegacySlots)
      (when (not (null (getd name))) (setq gone nil)))
    (foreach property (__pyTestLegacyProperties)
      (setq propertyList (plist (car property)))
      (when (__pyTestPropertyPresentp (cadr property) propertyList) (setq gone nil)))
    gone))

(defun __pyTestPublicSurfacePresent ()
  (let ((present t))
    (foreach name '(pyStartServer pyKillServer pyRestartServer pyReloadScript pyShowLog pyRunScript
                    __pyIpcBeginProcess __pyIpcKillProcess __pyIpcWriteProcess __pyIpcWait)
      (when (null (getd name)) (setq present nil)))
    present))

(defun __pyTestFinishedp (id ids)
  (if ids
      (if (equal id (car ids)) t (__pyTestFinishedp id (cdr ids)))
      nil))

(defun __pyTestWithFakeIpc (handles waitResult thunk)
  (let ((originalBegin (getd '__pyIpcBeginProcess))
        (originalWrite (getd '__pyIpcWriteProcess))
        (originalKill (getd '__pyIpcKillProcess))
        (originalWait (getd '__pyIpcWait))
        (originalPythonPath (getShellEnvVar "PYTHONPATH"))
        installedBegin
        installedWrite
        installedKill
        installedWait
        accessors)
    handles["begins"] = nil
    handles["writes"] = nil
    handles["kills"] = nil
    handles["waits"] = nil
    handles["finished"] = nil
    accessors = list(nil 'begins (lambda () handles["begins"])
                     'writes (lambda () handles["writes"])
                     'kills (lambda () handles["kills"])
                     'waits (lambda () handles["waits"]))
    unwindProtect(
      progn(
        (setq installedBegin
          (lambda (command host dataHandler errorHandler postHandler logFile)
            let((handle wrappedPost)
              handle = if(handles["handle"] then handles["handle"]
                          else gensym("__py_test_child_"))
              (setq wrappedPost
                (lambda (id status)
                  handles["finished"] = cons(id handles["finished"])
                  funcall(postHandler id status)))
              handles["begins"] = append(handles["begins"]
                list(list(if(handles["failBegin"] then nil else handle)
                          command host dataHandler errorHandler wrappedPost logFile
                          (getShellEnvVar "PYTHONPATH"))))
              if(handles["failBegin"] then nil else handle))))
        (setq installedWrite
          (lambda (process data)
            handles["writes"] = append(handles["writes"] list(list(process data))) t))
        (setq installedKill
          (lambda (process)
            handles["kills"] = append(handles["kills"] list(process)) t))
        (setq installedWait
          (lambda (process)
            handles["waits"] = append(handles["waits"] list(process)) waitResult))
        putd('__pyIpcBeginProcess installedBegin)
        putd('__pyIpcWriteProcess installedWrite)
        putd('__pyIpcKillProcess installedKill)
        putd('__pyIpcWait installedWait)
        funcall(thunk accessors))
      progn(
        when(handles["begins"] pyKillServer())
        when(handles["begins"]
          foreach(begin handles["begins"]
            when(and(nth(0 begin) nth(5 begin)
                     (not (__pyTestFinishedp (nth 0 begin) handles["finished"])))
              funcall(nth(5 begin) nth(0 begin) 0))))
        when(eq(getd('__pyIpcBeginProcess) installedBegin)
          putd('__pyIpcBeginProcess originalBegin))
        when(eq(getd('__pyIpcWriteProcess) installedWrite)
          putd('__pyIpcWriteProcess originalWrite))
        when(eq(getd('__pyIpcKillProcess) installedKill)
          putd('__pyIpcKillProcess originalKill))
        when(eq(getd('__pyIpcWait) installedWait)
          putd('__pyIpcWait originalWait))
        if(originalPythonPath then setShellEnvVar("PYTHONPATH" originalPythonPath)
          else unsetShellEnvVar("PYTHONPATH"))
        handles["failBegin"] = nil
        t))))

(defun __pyTestRequestContextAfterWriteError ()
  (__pyTestWithFakeIpc (makeTable "write-error" nil) nil
    (lambda (accessors)
      (let (entry callback process failed fakeWrite errorWrite restartResult killCount)
        (pyStartServer)
        (setq entry (car (funcall (nth 2 accessors))))
        (setq process (nth 0 entry))
        (setq callback (nth 3 entry))
        (setq fakeWrite (getd '__pyIpcWriteProcess))
        (setq errorWrite
          (lambda (_process _data) (error "qtest write boom")))
        (putd '__pyIpcWriteProcess errorWrite)
        (setq failed (null (errset (funcall callback process "plus(1 2)\n"))))
        (setq restartResult (errset (pyRestartServer)))
        (setq killCount (length (funcall (nth 6 accessors))))
        (putd '__pyIpcWriteProcess fakeWrite)
        (list failed killCount)))))

(defun __pyTestReloadRejectsOldCallback ()
  (let ((handlesForReload (makeTable "reload" nil))
        (nestedHandles (makeTable "reload-nested" nil))
        old
        oldData
        oldProcess
        stopped
        killCount
        nested
        callables)
    handlesForReload["handle"] = 'reloadProcess
    nestedHandles["handle"] = 'reloadProcess
    (__pyTestWithFakeIpc handlesForReload nil
      (lambda (accessors)
        (pyStartServer)
        (setq old (car (funcall (nth 2 accessors))))
        (setq oldProcess (nth 0 old))
        (setq oldData (nth 3 old))
        (pyReloadScript)
        (setq stopped (pyKillServer))
        (setq killCount (length (funcall (nth 6 accessors))))
        (setq nested
          (__pyTestWithFakeIpc nestedHandles nil
            (lambda (newAccessors)
              (let (started newData writes)
                (setq started (pyStartServer))
                (setq newData (nth 3 (car (funcall (nth 2 newAccessors)))))
                (funcall oldData oldProcess "plus(1 2)\n")
                (funcall newData 'reloadProcess "plus(3 4)\n")
                (setq writes (mapcar 'cadr (funcall (nth 4 newAccessors))))
                (list writes started)))))
        (setq callables
          (list (__pyTestPublicSurfacePresent)))
        (list nested stopped killCount callables)))))

(qtest::runSuites
  (qtest::TestSuite ((actual nil) (handles (makeTable "s1" nil)))
    (qtest::TestCase test_serialize_boolean
      (setq actual (__pyTestWithFakeIpc handles nil (lambda (a)
        let((b cb p) p=pyRunScript("x") b=car(funcall(nth(2 a))) cb=nth(3 b)
          funcall(cb p "t\nnil\n") mapcar('cadr funcall(nth(4 a)))))))
      (qtest::assertEqual '("success True\n" "success None\n") actual))
    (qtest::TestCase test_serialize_numbers
      (setq actual (__pyTestWithFakeIpc handles nil (lambda (a)
        let((b cb p) p=pyRunScript("x") b=car(funcall(nth(2 a))) cb=nth(3 b)
          funcall(cb p "42\n-10\n3.14\n") mapcar('cadr funcall(nth(4 a)))))))
      ;;; %.17g exposes the true binary64 value of the literal 3.14; Python
      ;;; parses it back to the identical double, so Python-side == still holds.
      (qtest::assertEqual '("success 42\n" "success -10\n" "success 3.1400000000000001\n") actual))
    ;;; Float serialization is a wire-format contract, not a geometry tolerance.
    ;;; The legacy %L path follows Allegro's default print precision and loses
    ;;; significant digits before Python can decode the response.  Explicit
    ;;; %.17g must preserve binary64 values, while an integer-looking flonum
    ;;; receives .0 so Python keeps its float type; -0.0 must keep its sign.
    ;;; The nested list verifies that the same rule is applied recursively.
    (qtest::TestCase test_serialize_flonum_round_trip_preserves_type_and_sign
      (setq actual (__pyTestWithFakeIpc handles nil (lambda (a)
        let((b cb p) p=pyRunScript("x") b=car(funcall(nth(2 a))) cb=nth(3 b)
          funcall(cb p
            "(list 1.0 -0.0 0.12345678901234566 1.0000000000000002 (list 1.0 -0.0))\n")
          mapcar('cadr funcall(nth(4 a)))))))
      (qtest::assertEqual
        '("success [1.0,-0.0,0.12345678901234566,1.0000000000000002,[1.0,-0.0]]\n")
        actual))
    (qtest::TestCase test_serialize_string
      (setq actual (__pyTestWithFakeIpc handles nil (lambda (a)
        let((b cb p) p=pyRunScript("x") b=car(funcall(nth(2 a))) cb=nth(3 b)
          funcall(cb p "\"hello world\"\n\"\"\n") mapcar('cadr funcall(nth(4 a)))))))
      (qtest::assertEqual '("success \"hello world\"\n" "success \"\"\n") actual))
    (qtest::TestCase test_serialize_symbol
      (setq actual (__pyTestWithFakeIpc handles nil (lambda (a)
        let((b cb p) p=pyRunScript("x") b=car(funcall(nth(2 a))) cb=nth(3 b)
          funcall(cb p "'my_symbol\n") mapcar('cadr funcall(nth(4 a)))))))
      (qtest::assertEqual '("success Symbol('my_symbol')\n") actual))
    (qtest::TestCase test_script_unbound_result_is_reported_publicly
      (setq actual (__pyTestWithFakeIpc handles nil (lambda (a)
        let((b cb p)
          p=pyRunScript("x") b=car(funcall(nth(2 a))) cb=nth(3 b)
          funcall(cb p
            "makeTable(\"phase21-unbound-script\")[\"missing\"]\n")
          cadr(car(funcall(nth(4 a))))))))
      (qtest::assertEqual "success error('unbound')\n" actual)))

  (qtest::TestSuite ((actual nil) (handles (makeTable "s2" nil)))
    (qtest::TestCase test_serialize_list
      (setq actual (__pyTestWithFakeIpc handles nil (lambda (a)
        let((b cb p) p=pyRunScript("x") b=car(funcall(nth(2 a))) cb=nth(3 b)
          funcall(cb p "(list)\n(list 1 2 3)\n(list \"a\" t nil)\n(list 1 (list 2 3))\n")
          mapcar('cadr funcall(nth(4 a)))))))
      (qtest::assertEqual '("success None\n" "success [1,2,3]\n" "success [\"a\",True,None]\n" "success [1,[2,3]]\n") actual))
    (qtest::TestCase test_serialize_disembodied_property_list
      (setq actual (__pyTestWithFakeIpc handles nil (lambda (a)
        let((b cb p) p=pyRunScript("x") b=car(funcall(nth(2 a))) cb=nth(3 b)
          funcall(cb p "(list nil 'a 1 'b 2)\n(list nil 'name \"skillbridge\")\n")
          mapcar('cadr funcall(nth(4 a)))))))
      (qtest::assertEqual '("success {'a':1,'b':2}\n" "success {'name':\"skillbridge\"}\n") actual)))

  (qtest::TestSuite ((actual nil) (handles (makeTable "s2-float" nil)))
    ;;; DPL fields use propertyListToPython and must still recurse through the
    ;;; shared float formatter; Route and DRC projections depend on this path.
    (qtest::TestCase test_serialize_dpl_float_values_preserves_wire_contract
      (setq actual (__pyTestWithFakeIpc handles nil (lambda (a)
        let((b cb p) p=pyRunScript("x") b=car(funcall(nth(2 a))) cb=nth(3 b)
          funcall(cb p
            "(list nil 'point (list 1.0 -0.0 0.12345678901234566))\n")
          mapcar('cadr funcall(nth(4 a)))))))
      (qtest::assertEqual
        '("success {'point':[1.0,-0.0,0.12345678901234566]}\n")
        actual)))

  (qtest::TestSuite ((actual nil) (handles (makeTable "s3" nil)))
    (qtest::TestCase test_serialize_table
      (setq actual (__pyTestWithFakeIpc handles nil (lambda (a)
        let((b cb p) p=pyRunScript("x") b=car(funcall(nth(2 a))) cb=nth(3 b)
          funcall(cb p "(makeTable \"x\" nil)\n") car(funcall(nth(4 a)))))))
      (qtest::assertTrue (qub::startsWith (cadr actual) "success Table(\"__py_table_")))
    (qtest::TestCase test_serialize_vector
      (setq actual (__pyTestWithFakeIpc handles nil (lambda (a)
        let((b cb p) p=pyRunScript("x") b=car(funcall(nth(2 a))) cb=nth(3 b)
          funcall(cb p "(makeVector 2 nil)\n") car(funcall(nth(4 a)))))))
      (qtest::assertTrue (qub::startsWith (cadr actual) "success Vector(\"__py_vector_"))))

  (qtest::TestSuite ((actual nil) (handles (makeTable "initial" nil)))
    (qtest::TestCase test_server_initial_state
      (setq actual (__pyTestWithFakeIpc handles nil (lambda (_accessors)
        progn(pyStartServer()
              list((not (null (getd 'pyKillServer)))
                   (not (null (getd 'pyRestartServer)))
                   (not (null (getd 'pyReloadScript)))
                   (not (null (getd 'pyShowLog)))
                   (not (null (getd 'pyRunScript))))))))
      (qtest::assertEqual '(t t t t t) actual)))

  (qtest::TestSuite ((actual nil) (handles (makeTable "s5" nil)))
    (qtest::TestCase test_spawn_server_builds_all_command_variants
      (setq actual (__pyTestWithFakeIpc handles nil (lambda (a)
        let((bs p second)
          pyStartServer(?id "workspace" ?logLevel "DEBUG" ?python "python-test")
          bs=car(funcall(nth(2 a))) p=nth(5 bs) funcall(p nth(0 bs) 0)
          pyStartServer(?singleMode t ?forceTcp t ?timeout 2.5)
          second=cadr(funcall(nth(2 a))) funcall(nth(5 second) nth(0 second) 0)
          list(length(funcall(nth(2 a)))
            type(nth(3 bs)) type(nth(4 bs)) type(nth(5 bs))
            (type (nth 3 (cadr (funcall (nth 2 a)))))
            (type (nth 4 (cadr (funcall (nth 2 a)))))
            (type (nth 5 (cadr (funcall (nth 2 a))))))))))
      (qtest::assertEqual '(2 funobj funobj funobj funobj funobj funobj) actual))
    (qtest::TestCase test_spawn_server_passes_string_id_unquoted
      (setq actual (__pyTestWithFakeIpc handles nil (lambda (a)
        let((b) pyStartServer(?id "7777")
          b=car(funcall(nth(2 a))) nth(1 b)))))
      (qtest::assertEqual
        "\"python\" -m allegrobridge._kernel.server.python_server 7777 INFO"
        actual))
    (qtest::TestCase test_spawn_server_temporarily_sets_and_restores_pythonpath
      (setq actual (__pyTestWithFakeIpc handles nil (lambda (a)
        let((old first second post)
          old=getShellEnvVar("PYTHONPATH") unsetShellEnvVar("PYTHONPATH")
          pyStartServer() first=car(funcall(nth(2 a))) post=nth(5 first)
          funcall(post nth(0 first) 0)
          setShellEnvVar("PYTHONPATH" "qtest-original-path")
          pyStartServer() second=cadr(funcall(nth(2 a)))
           list(not(null(index(nth(6 second) "allegrobridge")))
                equal(getShellEnvVar("PYTHONPATH") "qtest-original-path"))))))
      (qtest::assertEqual '(t t) actual))
    (qtest::TestCase test_module_folder_is_package_parent
      (setq actual (__pyTestWithFakeIpc handles nil
        (lambda (a)
          let((begin)
            pyRunScript("x")
            begin=car(funcall(nth(2 a)))
            not(null(index(nth(6 begin) "allegrobridge")))))))
      (qtest::assertTrue actual))
    (qtest::TestCase test_start_server_reports_begin_failure
      handles["failBegin"] = t
      (setq actual (__pyTestWithFakeIpc handles nil (lambda (_accessors)
        pyStartServer())))
      handles["failBegin"] = nil
      (qtest::assertEqual nil actual))
    (qtest::TestCase test_kill_and_restart_lifecycle
      (setq actual (__pyTestWithFakeIpc handles nil (lambda (a)
        let((b)
          pyStartServer()
          b=car(funcall(nth(2 a))) pyKillServer()
          funcall(nth(5 b) nth(0 b) 0) pyRestartServer()
          list(length(funcall(nth(6 a))) length(funcall(nth(2 a)))
               length(funcall(nth(8 a))))))))
      (qtest::assertEqual '(1 2 0) actual)))

  (qtest::TestSuite ((actual nil))
    (qtest::TestCase test_show_log_handles_invalid_missing_and_ring_buffer_files
      (setq actual
        (let ((logFile (strcat (or (getShellEnvVar "ALLEGROBRIDGE_LOG_DIRECTORY") ".")
                               "/allegrobridge_skill.log"))
              (capture (outstring))
              oldOutput invalid missing empty short ring)
          (unwindProtect
            (progn
              (__pyTestWriteLines logFile '("one" "two" "three"))
              (setq oldOutput (symeval 'poport))
              (set 'poport capture)
              (setq invalid (pyShowLog 0))
              (deleteFile logFile)
              (setq missing (pyShowLog 2))
              (__pyTestWriteLines logFile nil)
              (setq empty (pyShowLog 2))
              (__pyTestWriteLines logFile '("one" "two" "three"))
              (setq short (pyShowLog 5))
              (setq ring (pyShowLog 2))
              (list invalid missing empty short ring (getOutstring capture)
                    (pyShowLog -1)))
            (progn
              (set 'poport oldOutput)
              (close capture)
              (deleteFile logFile)))))
      (qtest::assertEqual '(nil nil t t t "one\ntwo\nthree\ntwo\nthree\n" nil) actual)))

  (qtest::TestSuite ((actual nil) (handles (makeTable "s7" nil)))
    (qtest::TestCase test_serialized_control_character_text_stays_framed
      (setq actual
        (__pyTestWithFakeIpc handles nil (lambda (a)
          let((b c p) pyStartServer() b=car(funcall(nth(2 a)))
            p=nth(0 b) c=nth(3 b)
            funcall(c p "strcat(\"left\" strcat(intToChar(27)) \"middle\" strcat(intToChar(30)) \"right\")\n")
            cadr(car(funcall(nth(4 a))))))))
      (qtest::assertEqual
        (strcat
          (intToChar 2)
          (lsprintf "%L"
            (strcat "left"
                    (intToChar 27)
                    "middle"
                    (intToChar 30)
                    "right"))
          (intToChar 30))
        actual))
    (qtest::TestCase test_on_data_buffers_partial_and_multiple_lines
      (setq actual (__pyTestWithFakeIpc handles nil (lambda (a)
        let((b c p) pyStartServer() b=car(funcall(nth(2 a))) p=nth(0 b) c=nth(3 b)
          funcall(c p "plus(1 ") funcall(c 'stale "99)\n") funcall(c p "2)\r\n\r\n\nplus(3 4)\nplus(5 ")
          funcall(c p "6)\n") list(mapcar('cadr funcall(nth(4 a))) "")))))
      (qtest::assertEqual
        (list
          (list (strcat (intToChar 2) "3" (intToChar 30))
                (strcat (intToChar 2) "7" (intToChar 30))
                (strcat (intToChar 2) "11" (intToChar 30)))
          "")
        actual))
    (qtest::TestCase test_on_data_frames_crlf_split_and_empty_chunks
      (setq actual (__pyTestWithFakeIpc handles nil (lambda (a)
        let((b c p) pyStartServer() b=car(funcall(nth(2 a))) p=nth(0 b) c=nth(3 b)
          funcall(c p "plus(1 2)\r") funcall(c p "\n") funcall(c p "") funcall(c p "\n") funcall(c p "plus(3 4)\n")
          list(mapcar('cadr funcall(nth(4 a))) "")))))
      (qtest::assertEqual
        (list
          (list (strcat (intToChar 2) "3" (intToChar 30))
                (strcat (intToChar 2) "7" (intToChar 30)))
          "")
        actual))
    (qtest::TestCase test_server_unbound_result_is_framed_publicly
      (setq actual (__pyTestWithFakeIpc handles nil (lambda (a)
        let((b c p)
          pyStartServer() b=car(funcall(nth(2 a))) p=nth(0 b) c=nth(3 b)
          funcall(c p
            "makeTable(\"phase21-unbound-server\")[\"missing\"]\n")
          cadr(car(funcall(nth(4 a))))))))
      (qtest::assertEqual
        (strcat (intToChar 2) "error('unbound')" (intToChar 30))
        actual))
    (qtest::TestCase test_request_restart_emits_rst_before_kill
      (setq actual (__pyTestWithFakeIpc handles nil (lambda (a)
        let((b c p writes)
          pyStartServer() b=car(funcall(nth(2 a))) p=nth(0 b) c=nth(3 b)
          funcall(c p "pyRestartServer()\n")
          writes=mapcar('cadr funcall(nth(4 a)))
          list((car writes) (length (funcall (nth 6 a))))))))
      (qtest::assertEqual
        (lsprintf "%L" (strcat (intToChar 18) "True" (intToChar 30)))
        (lsprintf "%L" (car actual)))
      (qtest::assertEqual 0 (cadr actual)))
    (qtest::TestCase test_receive_buffer_follows_process_lifecycle
      (setq actual (__pyTestWithFakeIpc handles nil (lambda (a)
        let((b c p post b2 c2 p2 writes)
          pyStartServer() b=car(funcall(nth(2 a))) p=nth(0 b) c=nth(3 b) post=nth(5 b)
          funcall(c p "plus(1 ") funcall(post 'stale 0) funcall(c p "2)\n")
          funcall(c p "plus(3 ") funcall(post p 0) funcall(c p "4)\n")
          pyStartServer() b2=cadr(funcall(nth(2 a))) p2=nth(0 b2) c2=nth(3 b2)
          funcall(c2 p2 "4)\n") writes=mapcar('cadr funcall(nth(4 a)))
          list(length(writes) (car writes) (cadr writes))))))
      (qtest::assertEqual 2 (car actual))
      (qtest::assertTrue (qub::startsWith (cadr actual) (strcat (intToChar 2) "3")))
      (qtest::assertTrue (qub::startsWith (caddr actual) (strcat (intToChar 2))))
      (qtest::assertTrue (index (caddr actual) "warning"))
      (qtest::assertTrue (index (caddr actual) ", 4)"))
      (qtest::assertTrue (null (index (caddr actual) "7"))))
    (qtest::TestCase test_on_data_writes_error_unbound_warning_success_and_restart
      (setq actual (__pyTestWithFakeIpc handles nil (lambda (a)
        let((b c p old sentinel same restored writes)
          pyStartServer() b=car(funcall(nth(2 a))) p=nth(0 b) c=nth(3 b)
          old=symeval('woport) sentinel=outstring()
          unwindProtect(
            progn(
              set('woport sentinel)
              funcall(c p "error(\"qtest boom\")\n")
              funcall(c p "makeTable(\"u\")[\"x\"]\n")
              funcall(c p "plus(1 2)\n")
              funcall(c p "progn(warn(\"qtest warning\") 7)\n")
              pyRestartServer()
              funcall(c p "plus(2 3)\n")
              same=eq(symeval('woport) sentinel)
              writes=mapcar('cadr funcall(nth(4 a))))
            progn(
              set('woport old)
              restored=eq(symeval('woport) old)
              close(sentinel)))
          list(writes same restored)))))
      (qtest::assertEqual 5 (length (car actual)))
      (qtest::assertTrue (cadr actual))
      (qtest::assertTrue (caddr actual)))
    (qtest::TestCase test_on_data_captures_printf_into_warning_frame
      (setq actual (__pyTestWithFakeIpc handles nil (lambda (a)
        let((b c p old sentinel same restored writes)
          pyStartServer() b=car(funcall(nth(2 a))) p=nth(0 b) c=nth(3 b)
          old=symeval('poport) sentinel=outstring()
          unwindProtect(
            progn(
              set('poport sentinel)
              funcall(c p "progn(printf(\"hello\") 42)\n")
              same=eq(symeval('poport) sentinel)
              writes=mapcar('cadr funcall(nth(4 a))))
            progn(
              set('poport old)
              restored=eq(symeval('poport) old)
              close(sentinel)))
          list((car writes) same restored)))))
      (qtest::assertTrue (index (car actual) "warning("))
      (qtest::assertTrue (index (car actual) "hello"))
      (qtest::assertTrue (index (car actual) "42"))
      (qtest::assertTrue (cadr actual))
      (qtest::assertTrue (caddr actual)))
    (qtest::TestCase test_on_data_treats_inner_errset_as_success
      (setq actual (__pyTestWithFakeIpc handles nil (lambda (a)
        let((b c p s old same restored writes)
          pyStartServer() b=car(funcall(nth(2 a))) p=nth(0 b) c=nth(3 b)
          old=symeval('woport) s=outstring()
          unwindProtect(
            progn(
              set('woport s)
              funcall(c p "errset(error(\"qtest inner boom\"))\n")
              funcall(c p "error(\"qtest outer boom\")\n")
              same=eq(symeval('woport) s)
              writes=mapcar('cadr funcall(nth(4 a))))
            progn(
              set('woport old)
              restored=eq(symeval('woport) old)
              close(s)))
          list(writes same restored)))))
      (qtest::assertTrue (qub::startsWith (cadr (car actual)) (strcat (intToChar 21))))
      (qtest::assertTrue (null (index (cadr (car actual)) "qtest inner boom")))
      (qtest::assertTrue (cadr actual))
      (qtest::assertTrue (caddr actual)))
    (qtest::TestCase test_on_data_script_treats_inner_errset_as_success
      (setq actual (__pyTestWithFakeIpc handles nil (lambda (a)
        let((b c p s old same restored writes)
          p=pyRunScript("x") b=car(funcall(nth(2 a))) c=nth(3 b)
          old=symeval('woport) s=outstring()
          unwindProtect(
            progn(
              set('woport s)
              funcall(c p "errset(error(\"qtest inner boom\"))\n")
              funcall(c p "error(\"qtest outer boom\")\n")
              same=eq(symeval('woport) s)
              writes=mapcar('cadr funcall(nth(4 a))))
            progn(
              set('woport old)
              restored=eq(symeval('woport) old)
              close(s)))
          list(writes same restored)))))
      (qtest::assertTrue (qub::startsWith (cadr (car actual)) "failure "))
      (qtest::assertTrue (null (index (cadr (car actual)) "qtest inner boom")))
      (qtest::assertTrue (cadr actual))
      (qtest::assertTrue (caddr actual)))
    (qtest::TestCase test_on_data_script_writes_newline_protocol
      (setq actual (__pyTestWithFakeIpc handles nil (lambda (a)
        let((b c p) p=pyRunScript("x") b=car(funcall(nth(2 a))) p=nth(0 b) c=nth(3 b)
          funcall(c p "plus(1 2)\nerror(\"qtest boom\")\n") funcall(c p "makeTable(\"u\")[\"x\"]\n")
          funcall(c p "progn(warn(\"qtest warning\") 7)\n") funcall(c p "plus(3 4)\n\nplus(5 6)\n") mapcar('cadr funcall(nth(4 a)))))))
      (qtest::assertEqual 6 (length actual)))
    (qtest::TestCase test_on_finish_ignores_stale_and_restarts_current_process
      (setq actual (__pyTestWithFakeIpc handles nil (lambda (a)
        let((b post p staleBegins) pyStartServer() b=car(funcall(nth(2 a))) p=nth(0 b) post=nth(5 b)
          pyRestartServer() funcall(post 'stale 1)
          staleBegins=length(funcall(nth(2 a))) funcall(post p 0)
          list(staleBegins length(funcall(nth(2 a))) length(funcall(nth(6 a))))))))
      (qtest::assertEqual '(1 2 1) actual)))

  (qtest::TestSuite ((actual nil))
    (qtest::TestCase test_remote_serialization_handles_regex_and_port
      (setq actual
        (let (port bindings names result)
          (setq port (outstring))
          (unwindProtect
            (progn
              (setq bindings
                (__pyTestBindGlobals
                  (list (pcreCompile "abc") port)))
              (setq names (car bindings))
              (setq result
                (__pyTestWithFakeIpc (makeTable "r1" nil) nil
                  (lambda (accessors)
                    (let (entry callback process)
                      (setq process (pyRunScript "x"))
                      (setq entry (car (funcall (nth 2 accessors))))
                      (setq callback (nth 3 entry))
                      (funcall callback process (strcat (symbolToString (nth 0 names)) "\n"))
                      (funcall callback process (strcat (symbolToString (nth 1 names)) "\n"))
                      (mapcar 'cadr (funcall (nth 4 accessors)))))))
              result)
            (progn
              (when bindings (__pyTestRestoreGlobals (cadr bindings)))
              (when port (close port))))))
      (qtest::assertEqual 2 (length actual)))
    (qtest::TestCase test_remote_serialization_handles_other_object
      (setq actual
        (__pyTestWithFakeIpc (makeTable "r-other" nil) nil
          (lambda (accessors)
            (let (entry callback process)
              (setq process (pyRunScript "x"))
              (setq entry (car (funcall (nth 2 accessors))))
              (setq callback (nth 3 entry))
              (funcall callback process "getSymbolNamespace('car)\n")
              (cadr (car (funcall (nth 4 accessors))))))))
      (qtest::assertTrue
        (qub::startsWith actual "success Remote(\"__py_OTHER_")))
    (qtest::TestCase test_remote_serialization_reports_unhandled_funobj
      (setq actual
        (__pyTestWithFakeIpc (makeTable "r-fallback" nil) nil
          (lambda (accessors)
            (let (entry callback process)
              (setq process (pyRunScript "x"))
              (setq entry (car (funcall (nth 2 accessors))))
              (setq callback (nth 3 entry))
              (funcall callback process "getd('car)\n")
              (cadr (car (funcall (nth 4 accessors))))))))
      (qtest::assertTrue (qub::startsWith actual "success error("))
      (qtest::assertTrue (index actual "primop:car")))
    (qtest::TestCase test_remote_serialization_reuses_variable_for_identical_object
      (setq actual
        (let (first second bindings names result)
          (setq first (pcreCompile "abc"))
          (setq second (pcreCompile "def"))
          (unwindProtect
            (progn
              (setq bindings (__pyTestBindGlobals (list first second)))
              (setq names (car bindings))
              (setq result
                (__pyTestWithFakeIpc (makeTable "r2" nil) nil
                  (lambda (accessors)
                    (let (entry callback process)
                      (setq process (pyRunScript "x"))
                      (setq entry (car (funcall (nth 2 accessors))))
                      (setq callback (nth 3 entry))
                      (funcall callback process (strcat (symbolToString (nth 0 names)) "\n"))
                      (funcall callback process (strcat (symbolToString (nth 0 names)) "\n"))
                      (funcall callback process (strcat (symbolToString (nth 1 names)) "\n"))
                      (mapcar 'cadr (funcall (nth 4 accessors)))))))
              (list result (equal (car result) (cadr result))))
            (when bindings (__pyTestRestoreGlobals (cadr bindings))))))
      (qtest::assertTrue (cadr actual))
      (qtest::assertTrue (null (equal (nth 0 (car actual)) (nth 2 (car actual))))))
    (qtest::TestCase test_remote_serialization_reuses_variable_for_identical_port
      (setq actual
        (let (port bindings name result)
          (setq port (outstring))
          (unwindProtect
            (progn
              (setq bindings (__pyTestBindGlobals (list port)))
              (setq name (car (car bindings)))
              (setq result
                (__pyTestWithFakeIpc (makeTable "r3" nil) nil
                  (lambda (accessors)
                    (let (entry callback process)
                      (setq process (pyRunScript "x"))
                      (setq entry (car (funcall (nth 2 accessors))))
                      (setq callback (nth 3 entry))
                      (funcall callback process (strcat (symbolToString name) "\n"))
                      (funcall callback process (strcat (symbolToString name) "\n"))
                      (mapcar 'cadr (funcall (nth 4 accessors)))))))
              result)
            (progn
              (when bindings (__pyTestRestoreGlobals (cadr bindings)))
              (when port (close port))))))
      (qtest::assertEqual (car actual) (cadr actual))))

  (qtest::TestSuite ((actual nil) (handles (makeTable "s9" nil)))
    (qtest::TestCase test_start_server_rejects_duplicate_and_forwards_configuration
      (setq actual (__pyTestWithFakeIpc handles nil (lambda (a)
        let((x duplicate configured begins first post)
          x=pyStartServer()
          first=car(funcall(nth(2 a))) post=nth(5 first)
          duplicate=pyStartServer(?id "configured")
          funcall(post nth(0 first) 0)
          configured=pyStartServer(?id "configured" ?logLevel "DEBUG" ?singleMode t ?timeout 4.0 ?python "python-test" ?forceTcp t)
          begins=funcall(nth(2 a))
          list(x duplicate configured length(begins) (nth 1 (cadr begins)))))))
      (qtest::assertEqual '(t nil t 2 "\"python-test\" -m allegrobridge._kernel.server.python_server configured DEBUG --single --force-tcp --timeout 4.0") actual))
    (qtest::TestCase test_run_script_inherits_server_python_and_restores_pythonpath
      (setq actual (__pyTestWithFakeIpc handles nil (lambda (a)
        let((old b) old=getShellEnvVar("PYTHONPATH") pyStartServer(?python "server-python-exe") pyRunScript("x") b=cadr(funcall(nth(2 a)))
          list(nth(1 b) equal(getShellEnvVar("PYTHONPATH") old))))))
      (qtest::assertEqual '("\"server-python-exe\" -m allegrobridge._kernel._run_script \"x\"" t) actual))
    (qtest::TestCase test_run_script_restores_preexisting_pythonpath
      (setq actual (__pyTestWithFakeIpc handles nil (lambda (a) setShellEnvVar("PYTHONPATH" "preexisting-pythonpath") pyRunScript("x") getShellEnvVar("PYTHONPATH"))))
      (qtest::assertEqual "preexisting-pythonpath" actual))
    (qtest::TestCase test_run_script_returns_process_or_waits
      (setq actual (__pyTestWithFakeIpc handles t (lambda (a)
        let((x y b first second) x=pyRunScript("x" ?python "python-test" ?args '("a" "b")) y=pyRunScript("x" ?block t) b=funcall(nth(2 a))
          first=car(b) second=cadr(b)
          list(not(null(x)) not(null(y)) length(b)
            type(nth(3 first)) type(nth(4 first)) type(nth(5 first))
            type(nth(3 second)) type(nth(4 second)) type(nth(5 second))
            null(eq(nth(3 first) nth(3 second))) null(eq(nth(5 first) nth(5 second)))
            length(funcall(nth(8 a))))))))
      (qtest::assertEqual '(t t 2 funobj funobj funobj funobj funobj funobj t t 1) actual))
    (qtest::TestCase test_run_script_buffers_fragmented_interleaved_children
      (setq actual
        (__pyTestWithFakeIpc handles nil
          (lambda (accessors)
            (let (begins processA processB callbackA callbackB)
              (pyRunScript "a")
              (pyRunScript "b")
              (setq begins (funcall (nth 2 accessors)))
              (setq processA (nth 0 (car begins)))
              (setq processB (nth 0 (cadr begins)))
              (setq callbackA (nth 3 (car begins)))
              (setq callbackB (nth 3 (cadr begins)))
              (funcall callbackA processA "0")
              (funcall callbackB processB "3")
              (funcall callbackA processA "3\n")
              (funcall callbackB processB "0\n")
              (mapcar 'cadr (funcall (nth 4 accessors)))))))
      (qtest::assertEqual '("success 3\n" "success 30\n") actual))
    (qtest::TestCase test_run_script_reused_id_drops_late_callbacks
      (setq actual
        (__pyTestWithFakeIpc handles nil
          (lambda (accessors)
            (let (begins process newProcess oldEntry newEntry oldCallback newCallback oldPost newPost)
              handles["handle"] = list('shared)
              (setq process (pyRunScript "old"))
              (setq oldEntry (car (funcall (nth 2 accessors))))
              (setq oldCallback (nth 3 oldEntry))
              (setq oldPost (nth 5 oldEntry))
              (funcall oldCallback (list 'shared) "1")
              (funcall oldPost 'wrong 0)
              (funcall oldPost (list 'shared) 0)
              handles["handle"] = list('shared)
              (setq newProcess (pyRunScript "new"))
              (setq begins (funcall (nth 2 accessors)))
              (setq newEntry (cadr begins))
              (setq newCallback (nth 3 newEntry))
              (setq newPost (nth 5 newEntry))
              (funcall oldCallback (list 'shared) "2\n")
              (funcall newCallback (list 'shared) "0")
              (funcall oldPost (list 'shared) 0)
              (funcall newCallback (list 'shared) "7\n")
              (funcall newPost (list 'shared) 0)
              (funcall newCallback (list 'shared) "18\n")
              (list (listp process) (listp newProcess)
                    (equal process newProcess) (not (eq process newProcess))
                    (mapcar 'cadr (funcall (nth 4 accessors))))))))
      (qtest::assertEqual '(t t t t ("success 7\n")) actual))
    (qtest::TestCase test_reload_rejects_old_callback_and_preserves_public_api
      (setq actual (__pyTestReloadRejectsOldCallback))
      (qtest::assertEqual 1 (length (car (car actual))))
      (qtest::assertEqual
        (strcat (intToChar 2) "7" (intToChar 30))
        (car (car (car actual))))
      (qtest::assertEqual t (cadr (car actual)))
      (qtest::assertEqual nil (cadr actual))
      (qtest::assertEqual 1 (caddr actual))
      (qtest::assertTrue (car (cadddr actual))))

    (qtest::TestCase test_request_context_is_cleared_after_write_error
      (setq actual (__pyTestRequestContextAfterWriteError))
      (qtest::assertEqual '(t 1) actual)))

  (qtest::TestSuite ((actual nil))
    (qtest::TestCase test_fresh_load_removes_legacy_surface_and_keeps_user_property
      (setq actual
        (let ((moduleFile (strcat (qub::scriptDir)
                                  "/../../allegrobridge/_kernel/server/python_server.ils"))
              snapshot
              result)
          (setq snapshot (__pyTestSnapshotLegacySurface))
          (unwindProtect
            (progn
              (__pyTestSeedLegacySurface)
              (load moduleFile)
              (setq result
                (list (__pyTestLegacySurfaceGone)
                      (__pyTestPublicSurfacePresent)
                      (equal (get 'pyStartServer 'userProperty) 'keep)))
              result)
            (__pyTestRestoreLegacySurface snapshot))))
      (qtest::assertEqual '(t t t) actual)))

  (qtest::TestSuite ((actual nil) (handles (makeTable "hot-reload" nil)))
    (qtest::TestCase test_hot_reload_removes_legacy_surface_and_keeps_user_property
      (setq actual
        (let (snapshot)
          (setq snapshot (__pyTestSnapshotLegacySurface))
          (unwindProtect
            (__pyTestWithFakeIpc handles nil
              (lambda (_accessors)
                (__pyTestSeedLegacySurface)
                (pyStartServer)
                (pyReloadScript)
                (list (__pyTestLegacySurfaceGone)
                      (__pyTestPublicSurfacePresent)
                      (equal (get 'pyStartServer 'userProperty) 'keep))))
            (__pyTestRestoreLegacySurface snapshot))))
      (qtest::assertEqual '(t t t) actual)))

  (qtest::TestSuite ((actual nil))
    (qtest::TestCase test_real_ipc_callbacks_retain_lexical_data_after_return
      (setq actual
        (let (process data finished)
          (setq data "")
          (setq finished nil)
          (setq process
            (ipcBeginProcess
              "cmd /c echo lexical-data"
              ""
              (lambda (_id chunk) (setq data (strcat data chunk)))
              nil
              (lambda (_id status) (setq finished status))))
          (ipcWait process 1 10)
          (list (not (null process)) (index data "lexical-data") finished)))
      (qtest::assertTrue (car actual))
      (qtest::assertTrue (cadr actual))
      (qtest::assertEqual 0 (caddr actual)))))
