;;; Copyright (c) 2025-2026 Bai Junyan and contributors.
;;; SPDX-License-Identifier: LGPL-3.0-or-later
;;; test_server.ils - Unit tests for python_server.il using qtest

(qcover::load (strcat (qub::scriptDir) "/../../allegrobridge/_kernel/server/python_server.il"))

(defun __pyTestServerState ()
  (list pyStartServer.ipc pyStartServer.id pyStartServer.logLevel
        pyStartServer.singleMode pyStartServer.timeout pyStartServer.python
        pyStartServer.forceTcp pyStartServer.restartPending pyStartServer.requestIpc
        pyStartServer.receiveBuffer pyStartServer.state pyStartServer.moduleFolder
        pyStartServer.logName pyRunScript.logName pyReloadServer.filename
        pyShowLog.logName))

(defun __pyTestRestoreServerState (state)
  pyStartServer.ipc = nth(0 state)
  pyStartServer.id = nth(1 state)
  pyStartServer.logLevel = nth(2 state)
  pyStartServer.singleMode = nth(3 state)
  pyStartServer.timeout = nth(4 state)
  pyStartServer.python = nth(5 state)
  pyStartServer.forceTcp = nth(6 state)
  pyStartServer.restartPending = nth(7 state)
  pyStartServer.requestIpc = nth(8 state)
  pyStartServer.receiveBuffer = nth(9 state)
  pyStartServer.state = nth(10 state)
  pyStartServer.moduleFolder = nth(11 state)
  pyStartServer.logName = nth(12 state)
  pyRunScript.logName = nth(13 state)
  pyReloadServer.filename = nth(14 state)
  pyShowLog.logName = nth(15 state)
  t)

(defun __pyTestWriteLines (fileName lines)
  (let ((port (outfile fileName)))
    (unless port (error "test_server: cannot create temporary file %s" fileName))
    (unwindProtect
      (foreach line lines (fprintf port "%s\n" line))
      (close port)))
  t)

(defun __pyTestSetShowLogName (value)
  pyShowLog.logName = value)

(defun __pyTestBindGlobals (values)
  (let ((names nil) (snapshots nil) name)
    (foreach value values
      (setq name (gensym "__py_test_global_"))
      (setq snapshots
        (cons
          (list name
                (if (boundp name (theEnvironment))
                    (symeval name (theEnvironment))
                    'unbound))
          snapshots))
      (set name value)
      (setq names (cons name names)))
    (list (reverse names) (reverse snapshots))))

(defun __pyTestRestoreGlobals (snapshots)
  (foreach snapshot snapshots set(car(snapshot) cadr(snapshot)))
  t)

(defun __pyTestWithFakeIpc (handles waitResult thunk)
  (let ((originalBegin (getd '__pyIpcBeginProcess))
        (originalWrite (getd '__pyIpcWriteProcess))
        (originalKill (getd '__pyIpcKillProcess))
        (originalWait (getd '__pyIpcWait))
        (savedState (__pyTestServerState))
        (originalPythonPath (getShellEnvVar "PYTHONPATH"))
        accessors)
    handles["begins"] = nil
    handles["writes"] = nil
    handles["kills"] = nil
    handles["waits"] = nil
    accessors = list(nil 'begins (lambda () handles["begins"])
                     'writes (lambda () handles["writes"])
                     'kills (lambda () handles["kills"])
                     'waits (lambda () handles["waits"]))
    unwindProtect(
      progn(
        putd('__pyIpcBeginProcess
          (lambda (command host dataHandler errorHandler postHandler logFile)
            let((handle)
              handle = if(handles["handle"] then handles["handle"]
                          else gensym("__py_test_child_"))
              handles["begins"] = append(handles["begins"]
                list(list(handle command host dataHandler errorHandler postHandler logFile)))
              handle)))
        putd('__pyIpcWriteProcess
          (lambda (process data)
            handles["writes"] = append(handles["writes"] list(list(process data))) t))
        putd('__pyIpcKillProcess
          (lambda (process)
            handles["kills"] = append(handles["kills"] list(process)) t))
        putd('__pyIpcWait
          (lambda (process)
            handles["waits"] = append(handles["waits"] list(process)) waitResult))
        funcall(thunk accessors))
      progn(
        putd('__pyIpcBeginProcess originalBegin)
        putd('__pyIpcWriteProcess originalWrite)
        putd('__pyIpcKillProcess originalKill)
        putd('__pyIpcWait originalWait)
        if(originalPythonPath then setShellEnvVar("PYTHONPATH" originalPythonPath)
          else unsetShellEnvVar("PYTHONPATH"))
        __pyTestRestoreServerState(savedState)))))

(qtest::runSuites
  (qtest::TestSuite ((actual nil) (handles (makeTable "s1" nil)))
    (qtest::TestCase test_serialize_boolean
      (setq actual (__pyTestWithFakeIpc handles nil (lambda (a)
        let((b cb p) p=pyRunScript("x") b=car(funcall(nth(2 a))) cb=nth(3 b)
          funcall(cb p "t\nnil\n") mapcar('cadr funcall(nth(4 a)))))))
      (qtest::assertEqual '("success True\n" "success None\n") actual))
    (qtest::TestCase test_serialize_numbers
      (setq actual (__pyTestWithFakeIpc handles nil (lambda (a)
        let((b cb p) p=pyRunScript("x") b=car(funcall(nth(2 a))) cb=nth(3 b)
          funcall(cb p "42\n-10\n3.14\n") mapcar('cadr funcall(nth(4 a)))))))
      (qtest::assertEqual '("success 42\n" "success -10\n" "success 3.14\n") actual))
    (qtest::TestCase test_serialize_string
      (setq actual (__pyTestWithFakeIpc handles nil (lambda (a)
        let((b cb p) p=pyRunScript("x") b=car(funcall(nth(2 a))) cb=nth(3 b)
          funcall(cb p "\"hello world\"\n\"\"\n") mapcar('cadr funcall(nth(4 a)))))))
      (qtest::assertEqual '("success \"hello world\"\n" "success \"\"\n") actual))
    (qtest::TestCase test_serialize_symbol
      (setq actual (__pyTestWithFakeIpc handles nil (lambda (a)
        let((b cb p) p=pyRunScript("x") b=car(funcall(nth(2 a))) cb=nth(3 b)
          funcall(cb p "'my_symbol\n") mapcar('cadr funcall(nth(4 a)))))))
      (qtest::assertEqual '("success Symbol('my_symbol')\n") actual)))

  (qtest::TestSuite ((actual nil) (handles (makeTable "s2" nil)))
    (qtest::TestCase test_serialize_list
      (setq actual (__pyTestWithFakeIpc handles nil (lambda (a)
        let((b cb p) p=pyRunScript("x") b=car(funcall(nth(2 a))) cb=nth(3 b)
          funcall(cb p "(list)\n(list 1 2 3)\n(list \"a\" t nil)\n(list 1 (list 2 3))\n")
          mapcar('cadr funcall(nth(4 a)))))))
      (qtest::assertEqual '("success None\n" "success [1,2,3]\n" "success [\"a\",True,None]\n" "success [1,[2,3]]\n") actual))
    (qtest::TestCase test_serialize_disembodied_property_list
      (setq actual (__pyTestWithFakeIpc handles nil (lambda (a)
        let((b cb p) p=pyRunScript("x") b=car(funcall(nth(2 a))) cb=nth(3 b)
          funcall(cb p "(list nil 'a 1 'b 2)\n(list nil 'name \"skillbridge\")\n")
          mapcar('cadr funcall(nth(4 a)))))))
      (qtest::assertEqual '("success {'a':1,'b':2}\n" "success {'name':\"skillbridge\"}\n") actual)))

  (qtest::TestSuite ((actual nil) (handles (makeTable "s3" nil)))
    (qtest::TestCase test_serialize_table
      (setq actual (__pyTestWithFakeIpc handles nil (lambda (a)
        let((b cb p) p=pyRunScript("x") b=car(funcall(nth(2 a))) cb=nth(3 b)
          funcall(cb p "(makeTable \"x\" nil)\n") car(funcall(nth(4 a)))))))
      (qtest::assertTrue (qub::startsWith (cadr actual) "success Table(\"__py_table_")))
    (qtest::TestCase test_serialize_vector
      (setq actual (__pyTestWithFakeIpc handles nil (lambda (a)
        let((b cb p) p=pyRunScript("x") b=car(funcall(nth(2 a))) cb=nth(3 b)
          funcall(cb p "(makeVector 2 nil)\n") car(funcall(nth(4 a)))))))
      (qtest::assertTrue (qub::startsWith (cadr actual) "success Vector(\"__py_vector_"))))

  (qtest::TestSuite ((actual nil))
    (qtest::TestCase test_server_initial_state
      (setq actual (unwindProtect
        list(pyStartServer.state pyStartServer.id pyStartServer.logLevel pyStartServer.python
             pyStartServer.singleMode pyStartServer.timeout pyStartServer.forceTcp
             pyStartServer.receiveBuffer pyStartServer.ipc) nil))
      (qtest::assertEqual '(stopped "default" "INFO" "python" nil nil nil "" nil) actual)))

  (qtest::TestSuite ((actual nil) (handles (makeTable "s5" nil)))
    (qtest::TestCase test_spawn_server_builds_all_command_variants
      (setq actual (__pyTestWithFakeIpc handles nil (lambda (a)
        let((bs p second)
          pyStartServer.ipc=nil pyStartServer.id="workspace" pyStartServer.logLevel="DEBUG"
          pyStartServer.python="python-test" pyStartServer()
          bs=car(funcall(nth(2 a))) p=nth(5 bs) funcall(p nth(0 bs) 0)
          pyStartServer.singleMode=t pyStartServer.forceTcp=t pyStartServer.timeout=2.5
          pyStartServer() second=cadr(funcall(nth(2 a))) funcall(nth(5 second) nth(0 second) 0)
          list(length(funcall(nth(2 a))) pyStartServer.state
            type(nth(3 bs)) type(nth(4 bs)) type(nth(5 bs))
            (type (nth 3 (cadr (funcall (nth 2 a)))))
            (type (nth 4 (cadr (funcall (nth 2 a)))))
            (type (nth 5 (cadr (funcall (nth 2 a))))))))))
      (qtest::assertEqual '(2 stopped funobj funobj funobj funobj funobj funobj) actual))
    (qtest::TestCase test_spawn_server_passes_string_id_unquoted
      (setq actual (__pyTestWithFakeIpc handles nil (lambda (a)
        let((b) pyStartServer.ipc=nil pyStartServer.id="7777" pyStartServer()
          b=car(funcall(nth(2 a))) list(not(null(index("python_server 7777 INFO" nth(1 b))))
          index(nth(1 b) "\"7777\""))))))
      (qtest::assertEqual '(t nil) actual))
    (qtest::TestCase test_spawn_server_temporarily_sets_and_restores_pythonpath
      (setq actual (__pyTestWithFakeIpc handles nil (lambda (a)
        let((old) old=getShellEnvVar("PYTHONPATH") unsetShellEnvVar("PYTHONPATH")
          pyStartServer.ipc=nil pyStartServer() setShellEnvVar("PYTHONPATH" "qtest-original-path")
          pyStartServer.ipc=nil pyStartServer() getShellEnvVar("PYTHONPATH")))))
      (qtest::assertEqual "qtest-original-path" actual))
    (qtest::TestCase test_module_folder_is_package_parent
      (setq actual (unwindProtect
        list(isFile(strcat(pyStartServer.moduleFolder "/allegrobridge/__init__.py"))
             isFile(strcat(pyStartServer.moduleFolder "/__init__.py"))) nil))
      (qtest::assertEqual '(t nil) actual))
    (qtest::TestCase test_kill_and_restart_lifecycle
      (setq actual (__pyTestWithFakeIpc handles nil (lambda (a)
        let((b)
          pyStartServer.ipc=nil pyStartServer()
          b=car(funcall(nth(2 a))) pyKillServer()
          funcall(nth(5 b) nth(0 b) 0) pyRestartServer()
          list(pyStartServer.state length(funcall(nth(6 a))) length(funcall(nth(8 a))))))))
      (qtest::assertEqual '(running 1 0) actual)))

  (qtest::TestSuite ((actual nil) (savedLog nil))
    (qtest::TestCase test_show_log_handles_invalid_missing_and_ring_buffer_files
      (setq actual
        (let (emptyFile shortFile overflowFile missingFile)
          (setq savedLog pyShowLog.logName)
          (setq emptyFile (makeTempFileName (strcat (qub::scriptDir) "/qte")))
          (setq shortFile (makeTempFileName (strcat (qub::scriptDir) "/qts")))
          (setq overflowFile (makeTempFileName (strcat (qub::scriptDir) "/qto")))
          (setq missingFile (makeTempFileName (strcat (qub::scriptDir) "/qtm")))
          (unwindProtect
            (progn
              (__pyTestWriteLines emptyFile nil)
              (__pyTestWriteLines shortFile '("one" "two"))
              (__pyTestWriteLines overflowFile '("one" "two" "three"))
              (list (pyShowLog 0)
                    (progn (__pyTestSetShowLogName missingFile) (pyShowLog 2))
                    (progn (__pyTestSetShowLogName emptyFile) (pyShowLog 2))
                    (progn (__pyTestSetShowLogName shortFile) (pyShowLog 3))
                    (progn (__pyTestSetShowLogName overflowFile) (pyShowLog 2))))
            (progn
              (__pyTestSetShowLogName savedLog)
              (when emptyFile (deleteFile emptyFile))
              (when shortFile (deleteFile shortFile))
              (when overflowFile (deleteFile overflowFile))
              (when missingFile (deleteFile missingFile))))))
      (qtest::assertEqual '(nil nil t t t) actual)))

  (qtest::TestSuite ((actual nil) (handles (makeTable "s7" nil)))
    (qtest::TestCase test_frame_protocol_constants
      (setq actual (unwindProtect list(__pyWriteFrame.STX __pyWriteFrame.NAK __pyWriteFrame.RST
                                       __pyWriteFrame.ESC __pyWriteFrame.RS) nil))
      (qtest::assertEqual
        (list (strcat (intToChar 2))
              (strcat (intToChar 21))
              (strcat (intToChar 18))
              (strcat (intToChar 27))
              (strcat (intToChar 30)))
        actual))
    (qtest::TestCase test_write_frame_escapes_payload_delimiters
      (setq actual
        (let ((originalWrite (getd '__pyIpcWriteProcess)) writes)
          (unwindProtect
            (progn
              (putd '__pyIpcWriteProcess
                (lambda (process data)
                  (setq writes (cons (list process data) writes))))
              (__pyWriteFrame
                'process
                __pyWriteFrame.STX
                (strcat "left" __pyWriteFrame.ESC "middle" __pyWriteFrame.RS "right"))
              (car writes))
            (putd '__pyIpcWriteProcess originalWrite))))
      (qtest::assertEqual
        (list 'process
              (strcat __pyWriteFrame.STX
                      "left"
                      __pyWriteFrame.ESC
                      __pyWriteFrame.ESC
                      "middle"
                      __pyWriteFrame.ESC
                      __pyWriteFrame.RS
                      "right"
                      __pyWriteFrame.RS))
        actual))
    (qtest::TestCase test_on_data_buffers_partial_and_multiple_lines
      (setq actual (__pyTestWithFakeIpc handles nil (lambda (a)
        let((b c p) pyStartServer.ipc=nil pyStartServer() b=car(funcall(nth(2 a))) p=nth(0 b) c=nth(3 b)
          funcall(c p "plus(1 ") funcall(c 'stale "99)\n") funcall(c p "2)\r\n\r\n\nplus(3 4)\nplus(5 ")
          funcall(c p "6)\n") list(mapcar('cadr funcall(nth(4 a))) pyStartServer.receiveBuffer)))))
      (qtest::assertEqual
        (list
          (list (strcat __pyWriteFrame.STX "3" __pyWriteFrame.RS)
                (strcat __pyWriteFrame.STX "7" __pyWriteFrame.RS)
                (strcat __pyWriteFrame.STX "11" __pyWriteFrame.RS))
          "")
        actual))
    (qtest::TestCase test_on_data_frames_crlf_split_and_empty_chunks
      (setq actual (__pyTestWithFakeIpc handles nil (lambda (a)
        let((b c p) pyStartServer.ipc=nil pyStartServer() b=car(funcall(nth(2 a))) p=nth(0 b) c=nth(3 b)
          funcall(c p "plus(1 2)\r") funcall(c p "\n") funcall(c p "") funcall(c p "\n") funcall(c p "plus(3 4)\n")
          list(mapcar('cadr funcall(nth(4 a))) pyStartServer.receiveBuffer)))))
      (qtest::assertEqual
        (list
          (list (strcat __pyWriteFrame.STX "3" __pyWriteFrame.RS)
                (strcat __pyWriteFrame.STX "7" __pyWriteFrame.RS))
          "")
        actual))
    (qtest::TestCase test_receive_buffer_follows_process_lifecycle
      (setq actual (__pyTestWithFakeIpc handles nil (lambda (a)
        let((b p post) pyStartServer.receiveBuffer="old partial" pyStartServer.ipc=nil pyStartServer()
          b=car(funcall(nth(2 a))) p=nth(0 b) post=nth(5 b) list(pyStartServer.receiveBuffer
            (progn pyStartServer.receiveBuffer="current partial" funcall(post 'stale 0) pyStartServer.receiveBuffer)
            (progn funcall(post p 0) pyStartServer.receiveBuffer))))))
      (qtest::assertEqual '("" "current partial" "") actual))
    (qtest::TestCase test_on_data_writes_error_unbound_warning_success_and_restart
      (setq actual (__pyTestWithFakeIpc handles nil (lambda (a)
        let((b c p old sentinel same restored writes)
          pyStartServer.ipc=nil pyStartServer() b=car(funcall(nth(2 a))) p=nth(0 b) c=nth(3 b)
          old=symeval('woport) sentinel=outstring()
          unwindProtect(
            progn(
              set('woport sentinel)
              funcall(c p "error(\"qtest boom\")\n")
              funcall(c p "makeTable(\"u\")[\"x\"]\n")
              funcall(c p "plus(1 2)\n")
              funcall(c p "progn(warn(\"qtest warning\") 7)\n")
              pyStartServer.restartPending=t
              funcall(c p "plus(2 3)\n")
              same=eq(symeval('woport) sentinel)
              writes=mapcar('cadr funcall(nth(4 a))))
            progn(
              set('woport old)
              restored=eq(symeval('woport) old)
              close(sentinel)))
          list(writes same restored)))))
      (qtest::assertEqual 5 (length (car actual)))
      (qtest::assertTrue (cadr actual))
      (qtest::assertTrue (caddr actual)))
    (qtest::TestCase test_on_data_treats_inner_errset_as_success
      (setq actual (__pyTestWithFakeIpc handles nil (lambda (a)
        let((b c p s old same restored writes)
          pyStartServer.ipc=nil pyStartServer() b=car(funcall(nth(2 a))) p=nth(0 b) c=nth(3 b)
          old=symeval('woport) s=outstring()
          unwindProtect(
            progn(
              set('woport s)
              funcall(c p "errset(error(\"qtest inner boom\"))\n")
              funcall(c p "error(\"qtest outer boom\")\n")
              same=eq(symeval('woport) s)
              writes=mapcar('cadr funcall(nth(4 a))))
            progn(
              set('woport old)
              restored=eq(symeval('woport) old)
              close(s)))
          list(writes same restored)))))
      (qtest::assertTrue (qub::startsWith (cadr (car actual)) __pyWriteFrame.NAK))
      (qtest::assertTrue (null (index (cadr (car actual)) "qtest inner boom")))
      (qtest::assertTrue (cadr actual))
      (qtest::assertTrue (caddr actual)))
    (qtest::TestCase test_on_data_script_treats_inner_errset_as_success
      (setq actual (__pyTestWithFakeIpc handles nil (lambda (a)
        let((b c p s old same restored writes)
          p=pyRunScript("x") b=car(funcall(nth(2 a))) c=nth(3 b)
          old=symeval('woport) s=outstring()
          unwindProtect(
            progn(
              set('woport s)
              funcall(c p "errset(error(\"qtest inner boom\"))\n")
              funcall(c p "error(\"qtest outer boom\")\n")
              same=eq(symeval('woport) s)
              writes=mapcar('cadr funcall(nth(4 a))))
            progn(
              set('woport old)
              restored=eq(symeval('woport) old)
              close(s)))
          list(writes same restored)))))
      (qtest::assertTrue (qub::startsWith (cadr (car actual)) "failure "))
      (qtest::assertTrue (null (index (cadr (car actual)) "qtest inner boom")))
      (qtest::assertTrue (cadr actual))
      (qtest::assertTrue (caddr actual)))
    (qtest::TestCase test_on_data_script_writes_newline_protocol
      (setq actual (__pyTestWithFakeIpc handles nil (lambda (a)
        let((b c p) p=pyRunScript("x") b=car(funcall(nth(2 a))) p=nth(0 b) c=nth(3 b)
          funcall(c p "plus(1 2)\nerror(\"qtest boom\")\n") funcall(c p "makeTable(\"u\")[\"x\"]\n")
          funcall(c p "progn(warn(\"qtest warning\") 7)\n") funcall(c p "plus(3 4)\n\nplus(5 6)\n") mapcar('cadr funcall(nth(4 a)))))))
      (qtest::assertEqual 6 (length actual)))
    (qtest::TestCase test_on_finish_ignores_stale_and_restarts_current_process
      (setq actual (__pyTestWithFakeIpc handles nil (lambda (a)
        let((b post p) pyStartServer.ipc=nil pyStartServer() b=car(funcall(nth(2 a))) p=nth(0 b) post=nth(5 b)
          list(
            progn(funcall(post 'stale 1) list(pyStartServer.ipc pyStartServer.state))
            progn(funcall(post p 0) list(pyStartServer.ipc pyStartServer.state)))))))
      (qtest::assertEqual '((stale running) (nil stopped)) actual)))

  (qtest::TestSuite ((actual nil))
    (qtest::TestCase test_remote_serialization_handles_regex_other_port_and_fallback
      (setq actual
        (let (port bindings names result)
          (setq port (outstring))
          (unwindProtect
            (progn
              (setq bindings
                (__pyTestBindGlobals
                  (list (pcreCompile "abc") (qtest:::makeResult 'Pass "" nil nil) port)))
              (setq names (car bindings))
              (setq result
                (__pyTestWithFakeIpc (makeTable "r1" nil) nil
                  (lambda (accessors)
                    (let (entry callback process)
                      (setq process (pyRunScript "x"))
                      (setq entry (car (funcall (nth 2 accessors))))
                      (setq callback (nth 3 entry))
                      (funcall callback process (strcat (symbolToString (nth 0 names)) "\n"))
                      (funcall callback process (strcat (symbolToString (nth 1 names)) "\n"))
                      (funcall callback process (strcat (symbolToString (nth 2 names)) "\n"))
                      (mapcar 'cadr (funcall (nth 4 accessors)))))))
              result)
            (progn
              (when bindings (__pyTestRestoreGlobals (cadr bindings)))
              (when port (close port))))))
      (qtest::assertEqual 3 (length actual)))
    (qtest::TestCase test_remote_serialization_reuses_variable_for_identical_object
      (setq actual
        (let (first second bindings names result)
          (setq first (qtest:::makeResult 'Pass "" nil nil))
          (setq second (qtest:::makeResult 'Pass "" nil nil))
          (unwindProtect
            (progn
              (setq bindings (__pyTestBindGlobals (list first second)))
              (setq names (car bindings))
              (setq result
                (__pyTestWithFakeIpc (makeTable "r2" nil) nil
                  (lambda (accessors)
                    (let (entry callback process)
                      (setq process (pyRunScript "x"))
                      (setq entry (car (funcall (nth 2 accessors))))
                      (setq callback (nth 3 entry))
                      (funcall callback process (strcat (symbolToString (nth 0 names)) "\n"))
                      (funcall callback process (strcat (symbolToString (nth 0 names)) "\n"))
                      (funcall callback process (strcat (symbolToString (nth 1 names)) "\n"))
                      (mapcar 'cadr (funcall (nth 4 accessors)))))))
              (list result (equal (car result) (cadr result))))
            (when bindings (__pyTestRestoreGlobals (cadr bindings))))))
      (qtest::assertTrue (cadr actual))
      (qtest::assertTrue (null (equal (nth 0 (car actual)) (nth 2 (car actual))))))
    (qtest::TestCase test_remote_serialization_reuses_variable_for_identical_port
      (setq actual
        (let (port bindings name result)
          (setq port (outstring))
          (unwindProtect
            (progn
              (setq bindings (__pyTestBindGlobals (list port)))
              (setq name (car (car bindings)))
              (setq result
                (__pyTestWithFakeIpc (makeTable "r3" nil) nil
                  (lambda (accessors)
                    (let (entry callback process)
                      (setq process (pyRunScript "x"))
                      (setq entry (car (funcall (nth 2 accessors))))
                      (setq callback (nth 3 entry))
                      (funcall callback process (strcat (symbolToString name) "\n"))
                      (funcall callback process (strcat (symbolToString name) "\n"))
                      (mapcar 'cadr (funcall (nth 4 accessors)))))))
              result)
            (progn
              (when bindings (__pyTestRestoreGlobals (cadr bindings)))
              (when port (close port))))))
      (qtest::assertEqual (car actual) (cadr actual))))

  (qtest::TestSuite ((actual nil) (handles (makeTable "s9" nil)))
    (qtest::TestCase test_start_server_rejects_duplicate_and_forwards_configuration
      (setq actual (__pyTestWithFakeIpc handles nil (lambda (a)
        let((x y) pyStartServer.ipc='existing x=pyStartServer() pyStartServer.ipc=nil
          y=pyStartServer(?id "configured" ?logLevel "DEBUG" ?singleMode t ?timeout 4.0 ?python "python-test" ?forceTcp t)
          list(x y pyStartServer.id pyStartServer.logLevel pyStartServer.singleMode pyStartServer.timeout pyStartServer.python pyStartServer.forceTcp)))))
      (qtest::assertEqual '(nil t "configured" "DEBUG" t 4.0 "python-test" t) actual))
    (qtest::TestCase test_run_script_inherits_server_python_and_restores_pythonpath
      (setq actual (__pyTestWithFakeIpc handles nil (lambda (a)
        let((old b) old=getShellEnvVar("PYTHONPATH") pyStartServer.python="server-python-exe" pyRunScript("x") b=car(funcall(nth(2 a)))
          list(not(null(index(nth(1 b) "server-python-exe x"))) equal(getShellEnvVar("PYTHONPATH") old))))))
      (qtest::assertEqual '(t t) actual))
    (qtest::TestCase test_run_script_restores_preexisting_pythonpath
      (setq actual (__pyTestWithFakeIpc handles nil (lambda (a) setShellEnvVar("PYTHONPATH" "preexisting-pythonpath") pyRunScript("x") getShellEnvVar("PYTHONPATH"))))
      (qtest::assertEqual "preexisting-pythonpath" actual))
    (qtest::TestCase test_run_script_returns_process_or_waits
      (setq actual (__pyTestWithFakeIpc handles t (lambda (a)
        let((x y b first second) x=pyRunScript("x" ?python "python-test" ?args '("a" "b")) y=pyRunScript("x" ?block t) b=funcall(nth(2 a))
          first=car(b) second=cadr(b)
          list(not(null(x)) not(null(y)) length(b)
            type(nth(3 first)) type(nth(4 first)) type(nth(5 first))
            type(nth(3 second)) type(nth(4 second)) type(nth(5 second))
            null(eq(nth(3 first) nth(3 second))) null(eq(nth(5 first) nth(5 second)))
            length(funcall(nth(8 a))))))))
      (qtest::assertEqual '(t t 2 funobj funobj funobj funobj funobj funobj t t 1) actual))
    (qtest::TestCase test_run_script_buffers_fragmented_interleaved_children
      (setq actual
        (__pyTestWithFakeIpc handles nil
          (lambda (accessors)
            (let (begins processA processB callbackA callbackB)
              (pyRunScript "a")
              (pyRunScript "b")
              (setq begins (funcall (nth 2 accessors)))
              (setq processA (nth 0 (car begins)))
              (setq processB (nth 0 (cadr begins)))
              (setq callbackA (nth 3 (car begins)))
              (setq callbackB (nth 3 (cadr begins)))
              (funcall callbackA processA "plus(1 ")
              (funcall callbackB processB "plus(10 ")
              (funcall callbackA processA "2)\n")
              (funcall callbackB processB "20)\n")
              (mapcar 'cadr (funcall (nth 4 accessors)))))))
      (qtest::assertEqual '("success 3\n" "success 30\n") actual))
    (qtest::TestCase test_run_script_reused_id_drops_late_callbacks
      (setq actual
        (__pyTestWithFakeIpc handles nil
          (lambda (accessors)
            (let (begins process oldEntry newEntry oldCallback newCallback oldPost newPost)
              handles["handle"] = 'shared
              (setq process (pyRunScript "old"))
              (setq oldEntry (car (funcall (nth 2 accessors))))
              (setq oldCallback (nth 3 oldEntry))
              (setq oldPost (nth 5 oldEntry))
              (funcall oldCallback process "plus(1 ")
              (funcall oldPost process 0)
              (pyRunScript "new")
              (setq begins (funcall (nth 2 accessors)))
              (setq newEntry (cadr begins))
              (setq newCallback (nth 3 newEntry))
              (setq newPost (nth 5 newEntry))
              (funcall oldCallback process "2)\n")
              (funcall newCallback process "plus(3 ")
              (funcall oldPost process 0)
              (funcall newCallback process "4)\n")
              (funcall newPost process 0)
              (funcall newCallback process "plus(9 9)\n")
              (mapcar 'cadr (funcall (nth 4 accessors)))))))
      (qtest::assertEqual '("success 7\n") actual))
    (qtest::TestCase test_reload_rejects_old_callback_and_preserves_public_api
      (setq actual
        (let ((handlesForReload (makeTable "reload" nil))
              old
              oldData
              reloadIpc
              reloadBegins
              nested
              callables)
          handlesForReload["handle"] = 'reloadProcess
          (__pyTestWithFakeIpc handlesForReload nil
            (lambda (accessors)
              pyStartServer.ipc = nil
              (pyStartServer)
              (setq old (car (funcall (nth 2 accessors))))
              (setq oldData (nth 3 old))
              (pyReloadScript)
              (setq reloadIpc pyStartServer.ipc)
              (setq reloadBegins (length (funcall (nth 2 accessors))))
              (setq callables
                (list (not (null (getd 'pyStartServer)))
                      (not (null (getd 'pyKillServer)))
                      (not (null (getd 'pyRestartServer)))
                      (not (null (getd 'pyReloadScript)))
                      (not (null (getd 'pyShowLog)))
                      (not (null (getd 'pyRunScript)))))
              (setq nested
                (__pyTestWithFakeIpc handlesForReload nil
                  (lambda (newAccessors)
                    (let (entry data)
                      pyStartServer.ipc = nil
                      (pyStartServer)
                      (setq entry (car (funcall (nth 2 newAccessors))))
                      (setq data (nth 3 entry))
                      (funcall oldData 'reloadProcess "plus(1 2)\n")
                      (funcall data 'reloadProcess "plus(3 4)\n")
                      (mapcar 'cadr (funcall (nth 4 newAccessors)))))))
              (list nested reloadIpc reloadBegins callables)))))
      (qtest::assertEqual 1 (length (car actual)))
      (qtest::assertEqual
        (strcat __pyWriteFrame.STX "7" __pyWriteFrame.RS)
        (car (car actual)))
      (qtest::assertEqual nil (cadr actual))
      (qtest::assertEqual 1 (caddr actual))
      (qtest::assertEqual '(t t t t t t) (cadddr actual)))))
