;;; Copyright (c) 2025-2026 Bai Junyan and contributors.
;;; SPDX-License-Identifier: LGPL-3.0-or-later
;;; run.ils - Load qtest+qcover and run the test_*.ils suites with coverage.
;;; Each test file imports its own module under test (see the top of each test_*.ils).

;;; Run: load("/absolute/path/to/skillbridge/tests/skill/run.ils")

;;; Bootstrap: load qtest and qcover so the qub/qtest/qcover namespaces exist
;;; before the main form is parsed. The main form's qcover:: calls are read at
;;; parse time, not after the runtime loads below have run, so the namespaces
;;; must already exist when the reader reaches them.
(letseq ((_selfDir (letseq ((_filename (simplifyFilename (get_filename piport)))
                            (_normalized (buildString (parseString _filename "\\") "/"))
                            (_fileTail (rindex _normalized "/")))
                     (substring _normalized 1
                                (difference (strlen _normalized) (strlen _fileTail)))))
         (_qtestSrc (simplifyFilename (strcat _selfDir "/qtest/src")))
         (_oldSkillPath (getSkillPath)))
  (unwindProtect
    (progn
      (setSkillPath (cons _qtestSrc _oldSkillPath))
      (load (strcat _qtestSrc "/init.ils")))
    (setSkillPath _oldSkillPath)))

;;; Main: open the test board (the allegro_server projection suites read a real
;;; design), run framework self-tests, project suites, summary, then coverage.
(unwindProtect
  (progn
    (axlSetVariable "noconfirm" t)
    (unless
      (axlOpenDesign
        ?design (strcat (qub::scriptDir) "/../../allegrobridge/assets/shape1.brd")
        ?mode "wf")
      (error "ALLEGRO_TEST_BOARD_OPEN_FAILED"))
    (axlDBRefreshId (axlDBGetDesign))
    (load (strcat (qub::scriptDir) "/qtest/src/qtest/test_assertions.ils"))
    (load (strcat (qub::scriptDir) "/qtest/src/qtest/test_reporter.ils"))
    (load (strcat (qub::scriptDir) "/qtest/src/qcover/test_qcover.ils"))
    (load (strcat (qub::scriptDir) "/test_server.ils"))
    (load (strcat (qub::scriptDir) "/test_allegro_server.ils"))
    (load (strcat (qub::scriptDir) "/test_vias.ils"))
    (load (strcat (qub::scriptDir) "/test_routes.ils"))
    (load (strcat (qub::scriptDir) "/test_shapes.ils"))
    (load (strcat (qub::scriptDir) "/test_drc.ils"))
    (load (strcat (qub::scriptDir) "/test_run.ils"))
    (let ((failed (qtest::printSummary)))
      (when (greaterp failed 0)
        (error "qtest: %d tests failed" failed))
      (qcover::report ?minimum 100.0)))
  (qcover::reset))
