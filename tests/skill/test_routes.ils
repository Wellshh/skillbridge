;;; Copyright (c) 2025-2026 Bai Junyan and contributors.
;;; SPDX-License-Identifier: LGPL-3.0-or-later
;;; test_routes.ils - Unit tests for the lazy straight-route domain extension.

(qcover::load (strcat (qub::scriptDir)
                      "/../../allegrobridge/server/extensions/routes.il"))

(qtest::runSuites
  (qtest::TestSuite ()
    (qtest::TestCase test_route_projection_has_stable_attributes
      (letseq ((segment (list nil 'objType "line" 'layer "ETCH/TOP"
                              'startEnd '((1.0 2.0) (3.0 4.0)) 'width 0.2))
               (projected (__abProjectRoute segment "GND")))
        (qtest::assertEqual "GND" (get projected 'net))
        (qtest::assertEqual "ETCH/TOP" (get projected 'layer))
        (qtest::assertEqual 1.0 (get (get projected 'start) 'x))
        (qtest::assertEqual 2.0 (get (get projected 'start) 'y))
        (qtest::assertEqual 3.0 (get (get projected 'end) 'x))
        (qtest::assertEqual 4.0 (get (get projected 'end) 'y))
        (qtest::assertEqual 0.2 (get projected 'width))
        (qtest::assertEqual "line" (get projected 'obj_type))
        (qtest::assertNil (get projected 'length))
        (qtest::assertNil (get projected 'radius))
        (qtest::assertNil (get projected 'is_clockwise))
        (qtest::assertNil (get projected 'center))))

    (qtest::TestCase test_route_projection_decodes_arc_segment
      (letseq ((segment (list nil 'objType "arc" 'layer "ETCH/TOP"
                              'startEnd '((1.0 2.0) (3.0 4.0)) 'width 0.2
                              'radius 5.0 'isClockwise t 'xy '(2.0 3.0)))
               (projected (__abProjectRoute segment "CLK")))
        (qtest::assertEqual "arc" (get projected 'obj_type))
        (qtest::assertEqual "CLK" (get projected 'net))
        (qtest::assertEqual "ETCH/TOP" (get projected 'layer))
        (qtest::assertEqual 1.0 (get (get projected 'start) 'x))
        (qtest::assertEqual 5.0 (get projected 'radius))
        (qtest::assertTrue (get projected 'is_clockwise))
        (qtest::assertEqual 2.0 (get (get projected 'center) 'x))
        (qtest::assertEqual 3.0 (get (get projected 'center) 'y))
        (qtest::assertNil (get projected 'length))))

    (qtest::TestCase test_route_collection_filters_non_straight_etch
      (letseq ((line (list nil 'objType "line" 'layer "ETCH/TOP"
                           'startEnd '((1.0 2.0) (3.0 4.0)) 'width 0.2))
               (arc (list nil 'objType "arc" 'layer "ETCH/TOP"
                          'startEnd '((1.0 2.0) (3.0 4.0)) 'width 0.2
                          'radius 5.0 'isClockwise t 'xy '(2.0 3.0)))
               (etchPath (list nil 'objType "path" 'isEtch t
                               'segments (list line arc)))
               (linePath (list nil 'objType "path" 'isEtch nil
                               'segments (list line)))
               (other (list nil 'objType "via"))
               (paths (list etchPath linePath other)))
        (qtest::assertEqual 2 (length (__abCollectRoutePaths paths "GND" nil nil)))
        (qtest::assertEqual 2
                            (length (__abCollectRoutePaths paths "GND"
                                                           "ETCH/TOP" nil)))
        (qtest::assertNil (__abCollectRoutePaths paths "GND" "ETCH/BOTTOM" nil))))

    (qtest::TestCase test_routes_projection_lists_and_filters
      (let ((routes (__abProjectRoutes nil nil)))
        (qtest::assertTrue routes)
        (qtest::assertTrue (__abProjectRoutes (get (car routes) 'net) nil))
        (qtest::assertTrue (__abProjectRoutes nil (get (car routes) 'layer)))
        (qtest::assertNil (__abProjectRoutes "__MISSING_NET__" nil))
        (qtest::assertNil (__abProjectRoutes nil "__MISSING_LAYER__"))))

    (qtest::TestCase test_create_path_projects_created_segments
      (let ((originalPathStart (getd 'axlPathStart))
            (originalPathLine (getd 'axlPathLine))
            (originalPathArc (getd 'axlPathArcCenter))
            (originalCreate (getd '__abCreatePathObject))
            (debugModeBefore (status debugMode))
            result)
        (unwindProtect
          (progn
            (sstatus debugMode t)
            (putd 'axlPathStart (lambda (_pts _w) 'fakePath))
            (putd 'axlPathLine (lambda (_path _w _end) nil))
            (putd 'axlPathArcCenter (lambda (_path _w _end _cw _center) nil))
            (putd '__abCreatePathObject
              (lambda (_path _layer _net)
                (list
                  (list
                    (list nil 'objType "path" 'isEtch t
                          'net (list nil 'name _net)
                          'segments
                          (list (list nil 'objType "line" 'layer _layer
                                      'startEnd '((1.0 2.0) (3.0 4.0))
                                      'width 0.2))))
                  nil)))
            (setq result (__abCreatePath "GND" '(1.0 2.0)
                                         (list (list nil 'type "line" 'end '(3.0 4.0))
                                               (list nil 'type "arc" 'end '(5.0 6.0)
                                                     'clockwise t 'center '(2.0 3.0))
                                               (list nil 'type "unknown"))
                                         "ETCH/TOP" 0.2)))
          (progn
            (putd 'axlPathStart originalPathStart)
            (putd 'axlPathLine originalPathLine)
            (putd 'axlPathArcCenter originalPathArc)
            (putd '__abCreatePathObject originalCreate)
            (sstatus debugMode debugModeBefore)))
        (qtest::assertEqual 1 (length result))
        (qtest::assertEqual "GND" (get (car result) 'net))
        (qtest::assertEqual "line" (get (car result) 'obj_type))))

    (qtest::TestCase test_create_path_handles_dummy_net
      (let ((originalPathStart (getd 'axlPathStart))
            (originalPathLine (getd 'axlPathLine))
            (originalCreate (getd '__abCreatePathObject))
            (debugModeBefore (status debugMode))
            result)
        (unwindProtect
          (progn
            (sstatus debugMode t)
            (putd 'axlPathStart (lambda (_pts _w) 'fakePath))
            (putd 'axlPathLine (lambda (_path _w _end) nil))
            (putd '__abCreatePathObject
              (lambda (_path _layer _net)
                (list
                  (list
                    (list nil 'objType "path" 'isEtch t 'net ""
                          'segments
                          (list (list nil 'objType "line" 'layer _layer
                                      'startEnd '((1.0 2.0) (3.0 4.0))
                                      'width 0.2))))
                  nil)))
            (setq result (__abCreatePath "GND" '(1.0 2.0)
                                         (list (list nil 'type "line" 'end '(3.0 4.0)))
                                         "ETCH/TOP" 0.2)))
          (progn
            (putd 'axlPathStart originalPathStart)
            (putd 'axlPathLine originalPathLine)
            (putd '__abCreatePathObject originalCreate)
            (sstatus debugMode debugModeBefore)))
        (qtest::assertEqual 1 (length result))
        (qtest::assertNil (get (car result) 'net))))

    (qtest::TestCase test_create_path_rejects_nil_result
      (let ((originalPathStart (getd 'axlPathStart))
            (originalPathLine (getd 'axlPathLine))
            (originalCreate (getd '__abCreatePathObject))
            (debugModeBefore (status debugMode))
            result
            failureText)
        (unwindProtect
          (progn
            (sstatus debugMode t)
            (putd 'axlPathStart (lambda (_pts _w) 'fakePath))
            (putd 'axlPathLine (lambda (_path _w _end) nil))
            (putd '__abCreatePathObject (lambda (_path _layer _net) nil))
            (setq result (errset (__abCreatePath "GND" '(1.0 2.0)
                                                 (list (list nil 'type "line" 'end '(3.0 4.0)))
                                                 "ETCH/TOP" 0.2)))
            (setq failureText (sprintf nil "%L" errset.errset)))
          (progn
            (putd 'axlPathStart originalPathStart)
            (putd 'axlPathLine originalPathLine)
            (putd '__abCreatePathObject originalCreate)
            (sstatus debugMode debugModeBefore)))
        (qtest::assertNil result)
        (qtest::assertTrue (index failureText "ROUTE_CREATE_FAILED"))))

    (qtest::TestCase test_connect_routes_returns_pre_shell_pure_snapshot
      (letseq ((routes (__abProjectRoutes nil nil))
               sample
               net
               layer
               start
               end
               width
               (originalShell (getd '__abRouteShell))
               command
               result)
        (foreach route routes
          (when (and (null sample) (get route 'net))
            (setq sample route)))
        (setq net (get sample 'net))
        (setq layer (get sample 'layer))
        (setq start (list (get (get sample 'start) 'x)
                          (get (get sample 'start) 'y)))
        (setq end (list (get (get sample 'end) 'x)
                        (get (get sample 'end) 'y)))
        (setq width (get sample 'width))
        (unwindProtect
          (progn
            (putd '__abRouteShell (lambda (value) (setq command value)))
            (setq result (__abConnectRoutes net start end layer width)))
          (putd '__abRouteShell originalShell))
        (qtest::assertEqual (__abProjectRoutes net nil) result)
        (qtest::assertEqual
          (lsprintf "add connect -net %L -layer %s -width %.17g; pick %.17g %.17g; pick %.17g %.17g; done"
                    net layer width (car start) (cadr start) (car end) (cadr end))
          command)
        (qtest::assertNil (get (car result) 'dbid))))

    ;;; Precision contract regression: %L float rendering keeps only ~7 significant
    ;;; digits (12345678.9 -> "1.234568e+007"), so a revert to %L picks fails the
    ;;; template equality below. Covers tiny, large, and non-integer coordinates.
    (qtest::TestCase test_connect_routes_command_preserves_float_precision
      (letseq ((routes (__abProjectRoutes nil nil))
               sample
               net
               layer
               (start (list 0.0000001 12345678.9))
               (end (list 0.1 2.5))
               (width 0.0001)
               (originalShell (getd '__abRouteShell))
               command)
        (foreach route routes
          (when (and (null sample) (get route 'net))
            (setq sample route)))
        (setq net (get sample 'net))
        (setq layer (get sample 'layer))
        (unwindProtect
          (progn
            (putd '__abRouteShell (lambda (value) (setq command value)))
            (__abConnectRoutes net start end layer width))
          (putd '__abRouteShell originalShell))
        (qtest::assertEqual
          (lsprintf "add connect -net %L -layer %s -width %.17g; pick %.17g %.17g; pick %.17g %.17g; done"
                    net layer width (car start) (cadr start) (car end) (cadr end))
          command)
        ;;; the lossy ~7-digit %L rendering must not appear anywhere in the picks
        (qtest::assertNil (index command "1.234568e"))))

    ;;; Net names may carry inner spaces; %L quoting must hand the CLI one token.
    (qtest::TestCase test_connect_routes_command_quotes_net_with_inner_space
      (letseq ((routes (__abProjectRoutes nil nil))
               sample
               layer
               (net "MY NET")
               (originalShell (getd '__abRouteShell))
               (originalNetExists (getd '__abRouteNetExists))
               command)
        (foreach route routes
          (when (and (null sample) (get route 'layer))
            (setq sample route)))
        (setq layer (get sample 'layer))
        (unwindProtect
          (progn
            (putd '__abRouteShell (lambda (value) (setq command value)))
            (putd '__abRouteNetExists (lambda (_design _net) t))
            (__abConnectRoutes net '(1.0 2.0) '(3.0 4.0) layer 0.2))
          (progn
            (putd '__abRouteShell originalShell)
            (putd '__abRouteNetExists originalNetExists)))
        (qtest::assertTrue (index command "-net \"MY NET\""))))

    (qtest::TestCase test_connect_routes_rejects_missing_net_and_layer
      (letseq ((routes (__abProjectRoutes nil nil))
               sample
               net
               start
               end
               width
               missingNet
               missingLayer
               missingNetText
               missingLayerText)
        (foreach route routes
          (when (and (null sample) (get route 'net))
            (setq sample route)))
        (setq net (get sample 'net))
        (setq start (list (get (get sample 'start) 'x)
                          (get (get sample 'start) 'y)))
        (setq end (list (get (get sample 'end) 'x)
                        (get (get sample 'end) 'y)))
        (setq width (get sample 'width))
        (setq missingNet
              (errset (__abConnectRoutes "__MISSING_NET__" start end
                                          (get sample 'layer) width)))
        (setq missingNetText (sprintf nil "%L" errset.errset))
        (setq missingLayer
              (errset (__abConnectRoutes net start end "__MISSING_LAYER__" width)))
        (setq missingLayerText (sprintf nil "%L" errset.errset))
        (qtest::assertNil missingNet)
        (qtest::assertTrue (index missingNetText "ROUTE_CONNECT_NET_NOT_FOUND"))
        (qtest::assertNil missingLayer)
        (qtest::assertTrue (index missingLayerText "ROUTE_CONNECT_LAYER_NOT_FOUND"))))

    (qtest::TestCase test_connect_routes_propagates_shell_error
      (letseq ((routes (__abProjectRoutes nil nil))
               sample
               (originalShell (getd '__abRouteShell))
               result
               failureText)
        (foreach route routes
          (when (and (null sample) (get route 'net))
            (setq sample route)))
        (unwindProtect
          (progn
            (putd '__abRouteShell
                  (lambda (_command) (error "SHELL_PROBE_FAILED")))
            (setq result
                  (errset
                    (__abConnectRoutes
                      (get sample 'net)
                      (list (get (get sample 'start) 'x)
                            (get (get sample 'start) 'y))
                      (list (get (get sample 'end) 'x)
                            (get (get sample 'end) 'y))
                      (get sample 'layer)
                      (get sample 'width))))
            (setq failureText (sprintf nil "%L" errset.errset)))
          (putd '__abRouteShell originalShell))
        (qtest::assertNil result)
        (qtest::assertTrue (index failureText "SHELL_PROBE_FAILED"))))))
