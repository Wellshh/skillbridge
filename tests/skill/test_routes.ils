;;; Copyright (c) 2025-2026 Bai Junyan and contributors.
;;; SPDX-License-Identifier: LGPL-3.0-or-later
;;; test_routes.ils - Unit tests for the lazy straight-route domain extension.

(qcover::load (strcat (qub::scriptDir)
                      "/../../allegrobridge/server/extensions/routes.il"))

(qtest::runSuites
  (qtest::TestSuite ()
    (qtest::TestCase test_route_projection_has_stable_attributes
      (letseq ((segment (list nil 'objType "line" 'layer "ETCH/TOP"
                              'startEnd '((1.0 2.0) (3.0 4.0)) 'width 0.2))
               (projected (__abProjectRoute segment "GND")))
        (qtest::assertEqual "GND" (get projected 'net))
        (qtest::assertEqual "ETCH/TOP" (get projected 'layer))
        (qtest::assertEqual 1.0 (get (get projected 'start) 'x))
        (qtest::assertEqual 2.0 (get (get projected 'start) 'y))
        (qtest::assertEqual 3.0 (get (get projected 'end) 'x))
        (qtest::assertEqual 4.0 (get (get projected 'end) 'y))
        (qtest::assertEqual 0.2 (get projected 'width))
        (qtest::assertEqual "line" (get projected 'obj_type))
        (qtest::assertNil (get projected 'length))
        (qtest::assertNil (get projected 'radius))
        (qtest::assertNil (get projected 'is_clockwise))
        (qtest::assertNil (get projected 'center))))

    (qtest::TestCase test_route_projection_decodes_arc_segment
      (letseq ((segment (list nil 'objType "arc" 'layer "ETCH/TOP"
                              'startEnd '((1.0 2.0) (3.0 4.0)) 'width 0.2
                              'radius 5.0 'isClockwise t 'xy '(2.0 3.0)))
               (projected (__abProjectRoute segment "CLK")))
        (qtest::assertEqual "arc" (get projected 'obj_type))
        (qtest::assertEqual "CLK" (get projected 'net))
        (qtest::assertEqual "ETCH/TOP" (get projected 'layer))
        (qtest::assertEqual 1.0 (get (get projected 'start) 'x))
        (qtest::assertEqual 5.0 (get projected 'radius))
        (qtest::assertTrue (get projected 'is_clockwise))
        (qtest::assertEqual 2.0 (get (get projected 'center) 'x))
        (qtest::assertEqual 3.0 (get (get projected 'center) 'y))
        (qtest::assertNil (get projected 'length))))

    (qtest::TestCase test_route_collection_filters_non_straight_etch
      (letseq ((line (list nil 'objType "line" 'layer "ETCH/TOP"
                           'startEnd '((1.0 2.0) (3.0 4.0)) 'width 0.2))
               (arc (list nil 'objType "arc" 'layer "ETCH/TOP"
                          'startEnd '((1.0 2.0) (3.0 4.0)) 'width 0.2
                          'radius 5.0 'isClockwise t 'xy '(2.0 3.0)))
               (etchPath (list nil 'objType "path" 'isEtch t
                               'segments (list line arc)))
               (linePath (list nil 'objType "path" 'isEtch nil
                               'segments (list line)))
               (other (list nil 'objType "via"))
               (paths (list etchPath linePath other)))
        (qtest::assertEqual 2 (length (__abCollectRoutePaths paths "GND" nil nil)))
        (qtest::assertEqual 2
                            (length (__abCollectRoutePaths paths "GND"
                                                           "ETCH/TOP" nil)))
        (qtest::assertNil (__abCollectRoutePaths paths "GND" "ETCH/BOTTOM" nil))))

    (qtest::TestCase test_routes_projection_lists_and_filters
      (let ((routes (__abProjectRoutes nil nil)))
        (qtest::assertTrue routes)
        (qtest::assertTrue (__abProjectRoutes (get (car routes) 'net) nil))
        (qtest::assertTrue (__abProjectRoutes nil (get (car routes) 'layer)))
        (qtest::assertNil (__abProjectRoutes "__MISSING_NET__" nil))
        (qtest::assertNil (__abProjectRoutes nil "__MISSING_LAYER__"))))

    (qtest::TestCase test_create_route_projects_created_segments
      (let ((originalCreate (getd '__abCreateLineObject))
            result)
        (unwindProtect
          (progn
            (putd '__abCreateLineObject
                  (lambda (_points width layer net)
                    (list
                      (list
                        (list nil 'objType "path" 'isEtch t
                              'net (list nil 'name net)
                              'segments
                              (list (list nil 'objType "line" 'layer layer
                                          'startEnd '((1.0 2.0) (3.0 4.0))
                                          'width width))))
                      nil)))
            (setq result (__abCreateRoute "GND" '((1.0 2.0) (3.0 4.0))
                                                  "ETCH/TOP" 0.2)))
          (putd '__abCreateLineObject originalCreate))
        (qtest::assertEqual 1 (length result))
        (qtest::assertEqual "GND" (get (car result) 'net))))

    (qtest::TestCase test_create_route_handles_dummy_net
      (let ((originalCreate (getd '__abCreateLineObject))
            result)
        (unwindProtect
          (progn
            (putd '__abCreateLineObject
                  (lambda (_points width layer _net)
                    (list
                      (list
                        (list nil 'objType "path" 'isEtch t 'net ""
                              'segments
                              (list (list nil 'objType "line" 'layer layer
                                          'startEnd '((1.0 2.0) (3.0 4.0))
                                          'width width))))
                      nil)))
            (setq result (__abCreateRoute "GND" '((1.0 2.0) (3.0 4.0))
                                                  "ETCH/TOP" 0.2)))
          (putd '__abCreateLineObject originalCreate))
        (qtest::assertNil (get (car result) 'net))))

    (qtest::TestCase test_create_route_rejects_nil_result
      (let ((originalCreate (getd '__abCreateLineObject))
            result
            failureText)
        (unwindProtect
          (progn
            (putd '__abCreateLineObject (lambda (_points _width _layer _net) nil))
            (setq result (errset (__abCreateRoute "GND" '((1.0 2.0) (3.0 4.0))
                                                         "ETCH/TOP" 0.2)))
            (setq failureText (sprintf nil "%L" errset.errset)))
          (putd '__abCreateLineObject originalCreate))
        (qtest::assertNil result)
        (qtest::assertTrue (index failureText "ROUTE_CREATE_FAILED"))))

    (qtest::TestCase test_create_path_projects_created_segments
      (let ((originalPathStart (getd 'axlPathStart))
            (originalPathLine (getd 'axlPathLine))
            (originalPathArc (getd 'axlPathArcCenter))
            (originalCreate (getd '__abCreatePathObject))
            (debugModeBefore (status debugMode))
            result)
        (unwindProtect
          (progn
            (sstatus debugMode t)
            (putd 'axlPathStart (lambda (_pts _w) 'fakePath))
            (putd 'axlPathLine (lambda (_path _w _end) nil))
            (putd 'axlPathArcCenter (lambda (_path _w _end _cw _center) nil))
            (putd '__abCreatePathObject
              (lambda (_path _layer _net)
                (list
                  (list
                    (list nil 'objType "path" 'isEtch t
                          'net (list nil 'name _net)
                          'segments
                          (list (list nil 'objType "line" 'layer _layer
                                      'startEnd '((1.0 2.0) (3.0 4.0))
                                      'width 0.2))))
                  nil)))
            (setq result (__abCreatePath "GND" '(1.0 2.0)
                                         (list (list nil 'type "line" 'end '(3.0 4.0))
                                               (list nil 'type "arc" 'end '(5.0 6.0)
                                                     'clockwise t 'center '(2.0 3.0))
                                               (list nil 'type "unknown"))
                                         "ETCH/TOP" 0.2)))
          (progn
            (putd 'axlPathStart originalPathStart)
            (putd 'axlPathLine originalPathLine)
            (putd 'axlPathArcCenter originalPathArc)
            (putd '__abCreatePathObject originalCreate)
            (sstatus debugMode debugModeBefore)))
        (qtest::assertEqual 1 (length result))
        (qtest::assertEqual "GND" (get (car result) 'net))
        (qtest::assertEqual "line" (get (car result) 'obj_type))))

    (qtest::TestCase test_create_path_rejects_nil_result
      (let ((originalPathStart (getd 'axlPathStart))
            (originalPathLine (getd 'axlPathLine))
            (originalCreate (getd '__abCreatePathObject))
            (debugModeBefore (status debugMode))
            result
            failureText)
        (unwindProtect
          (progn
            (sstatus debugMode t)
            (putd 'axlPathStart (lambda (_pts _w) 'fakePath))
            (putd 'axlPathLine (lambda (_path _w _end) nil))
            (putd '__abCreatePathObject (lambda (_path _layer _net) nil))
            (setq result (errset (__abCreatePath "GND" '(1.0 2.0)
                                                 (list (list nil 'type "line" 'end '(3.0 4.0)))
                                                 "ETCH/TOP" 0.2)))
            (setq failureText (sprintf nil "%L" errset.errset)))
          (progn
            (putd 'axlPathStart originalPathStart)
            (putd 'axlPathLine originalPathLine)
            (putd '__abCreatePathObject originalCreate)
            (sstatus debugMode debugModeBefore)))
        (qtest::assertNil result)
        (qtest::assertTrue (index failureText "ROUTE_CREATE_FAILED"))))))
