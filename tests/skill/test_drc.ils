;;; Copyright (c) 2025-2026 Bai Junyan and contributors.
;;; SPDX-License-Identifier: LGPL-3.0-or-later

(qcover::load (strcat (qub::scriptDir)
                      "/../../allegrobridge/server/extensions/drc.il"))

(qtest::runSuites
  (qtest::TestSuite ()
    (qtest::TestCase test_drc_projection_returns_stable_fields
      (letseq ((net (list nil 'objType "net" 'name "VCC"))
               (symbol (list nil 'objType "symbol" 'refdes "U3"))
               (pin (list nil 'objType "pin" 'number "14" 'component nil
                          'parent symbol 'net net))
               (marker (list nil 'name "Ts Allowed" 'type "PHYSICAL CONSTRAINTS"
                             'source "VOLTAGE" 'expected "NOT_ALLOWED"
                             'actual "ANYWHERE" 'layer "DRC ERROR CLASS/GND"
                             'xy '(1.0 2.0) 'bBox '((0.0 1.0) (2.0 3.0))
                             'violations (list pin)))
               (projected (__abProjectDrc marker))
               (objects (get projected 'objects)))
        (qtest::assertEqual "Ts Allowed" (get projected 'name))
        (qtest::assertEqual "PHYSICAL CONSTRAINTS" (get projected 'category))
        (qtest::assertEqual 1.0 (get (get projected 'location) 'x))
        (qtest::assertEqual 3.0 (get (get (get projected 'bbox) 'ur) 'y))
        (qtest::assertEqual "pin" (get (car objects) 'kind))
        (qtest::assertEqual "component" (get (cadr objects) 'kind))
        (qtest::assertEqual "net" (get (caddr objects) 'kind))
        (qtest::assertNil (get projected 'violations))))

    (qtest::TestCase test_drc_projection_projects_violation_figures_in_order
      (letseq ((net (list nil 'objType "net" 'name "GND"))
               ;; Real Allegro markers contain at most two violation figures.
               ;; Route figures may have no xy (as observed on shape1); retain
               ;; one populated xy fixture to cover the optional branch.
               (line (list nil 'objType "line" 'layer "ETCH/TOP"
                           'bBox '((1.0 2.0) (3.0 4.0)) 'net net))
               (lineWithXY (list nil 'objType "line" 'layer "ETCH/BOTTOM"
                                  'xy '(7.0 8.0) 'net net))
               (marker (list nil 'name "Line spacing" 'type "PHYSICAL"
                             'source "DEFAULT" 'expected "10 MILS"
                             'actual "5 MILS" 'layer "DRC ERROR CLASS/TOP"
                             'xy '(5.0 6.0) 'bBox '((0.0 0.0) (6.0 6.0))
                             'violations (list line lineWithXY)))
               (projected (__abProjectDrc marker))
               (figures (get projected 'figures))
               (objects (get projected 'objects))
               (first (car figures))
               (second (cadr figures)))
        (qtest::assertEqual 2 (length figures))
        (qtest::assertEqual 1 (length objects))
        (qtest::assertEqual "line" (get first 'obj_type))
        (qtest::assertEqual "ETCH/TOP" (get first 'layer))
        (qtest::assertEqual 1.0 (get (get (get first 'bbox) 'll) 'x))
        (qtest::assertEqual "GND" (get (get first 'net) 'name))
        (qtest::assertNil (get first 'reference))
        (qtest::assertEqual "line" (get second 'obj_type))
        (qtest::assertEqual "ETCH/BOTTOM" (get second 'layer))
        (qtest::assertEqual 7.0 (get (get second 'location) 'x))
        (qtest::assertNil (get second 'bbox))
        (qtest::assertNil (get second 'reference))
        ;; An anonymous figure exercises all missing optional fields.
        (let ((anonymous (__abDrcFigure (list nil 'objType "polygon"))))
          (qtest::assertNil (get anonymous 'layer))
          (qtest::assertNil (get anonymous 'location))
          (qtest::assertNil (get anonymous 'bbox))
          (qtest::assertNil (get anonymous 'net))
          (qtest::assertNil (get anonymous 'reference)))))

    (qtest::TestCase test_drc_projection_omits_anonymous_geometry_and_duplicates
      (letseq ((net (list nil 'objType "net" 'name "GND"))
               (branch (list nil 'objType "branch" 'net net 'parent net))
               (tee (list nil 'objType "tee" 'net "GND"))
               (orphanShape (list nil 'objType "shape" 'net nil))
               (emptyNetShape (list nil 'objType "shape" 'net ""))
               (polygon (list nil 'objType "polygon"))
               (marker (list nil 'name "Spacing" 'type "NET SPACING CONSTRAINTS"
                             'source "DEFAULT" 'expected "10 MILS" 'actual "5 MILS"
                             'layer "DRC ERROR CLASS/GND" 'xy '(1.0 2.0)
                             'bBox '((0.0 1.0) (2.0 3.0))
                             'violations
                               (list branch tee orphanShape emptyNetShape polygon)))
               (objects (get (__abProjectDrc marker) 'objects)))
        (qtest::assertEqual 1 (length objects))
        (qtest::assertEqual "net" (get (car objects) 'kind))
        (qtest::assertEqual "GND" (get (car objects) 'name))))

    (qtest::TestCase test_drc_stable_refs_cover_component_and_component_pin
      (letseq ((component (list nil 'objType "component" 'name "U1"))
               (pin (list nil 'objType "pin" 'number "1" 'component component
                          'parent nil)))
        (qtest::assertEqual "component" (get (__abDrcStableRef component) 'kind))
        (qtest::assertEqual "U1" (get (__abDrcStableRef component) 'refdes))
        (qtest::assertEqual "U1" (get (__abDrcStableRef pin) 'refdes))
        (qtest::assertNil (__abDrcStableRef (list nil 'objType "polygon")))))

    (qtest::TestCase test_drc_projection_lists_current_design_markers
      (let ((design (__abFreshDesign))
            (drcs (__abProjectDrcs))
            hasDbid)
        (foreach drc drcs
          (when (get drc 'dbid)
            (setq hasDbid t)))
        (qtest::assertTrue
          (and drcs
               (equal (length design->drcs) (length drcs))
               (null hasDbid)))))

    (qtest::TestCase test_drc_item_resolves_stable_keys_and_projects_markers
      (letseq ((otherPin (list nil 'objType "pin" 'number "2"))
               (pin (list nil 'objType "pin" 'number "1"))
               (otherComponent (list nil 'objType "component" 'name "R2"
                                     'pins (list otherPin)))
               (component (list nil 'objType "component" 'name "R1"
                                'pins (list otherPin pin)))
               (otherNet (list nil 'objType "net" 'name "VCC"))
               (net (list nil 'objType "net" 'name "GND"))
               (design (list nil 'components (list otherComponent component)
                             'nets (list otherNet net)))
               (originalDesign (getd '__abFreshDesign))
               (originalCheck (getd '__abDrcCheckItem))
               result)
        (unwindProtect
          (progn
            (putd '__abFreshDesign (lambda () design))
            (putd '__abDrcCheckItem
                  (lambda (_target)
                    (list (list nil 'name "Spacing" 'type "PHYSICAL"
                                'source "DEFAULT" 'expected "10 MILS"
                                'actual "5 MILS" 'layer "DRC ERROR CLASS/TOP"
                                'xy '(1.0 2.0) 'bBox '((0.0 1.0) (2.0 3.0))
                                'violations nil))))
            (qtest::assertEqual component (__abFindDrcItem "component" "R1" nil))
            (qtest::assertEqual net (__abFindDrcItem "net" "GND" nil))
            (qtest::assertEqual pin (__abFindDrcItem "pin" "R1" "1"))
            (setq result (__abCheckDrcs "pin" "R1" "1")))
          (progn
            (putd '__abFreshDesign originalDesign)
            (putd '__abDrcCheckItem originalCheck)))
        (qtest::assertTrue
          (and (equal 1 (length result))
               (equal "Spacing" (get (car result) 'name))
               (null (get (car result) 'dbid))))))

    (qtest::TestCase test_drc_item_returns_nil_without_markers
      (let ((originalCheck (getd '__abDrcCheckItem))
            result)
        (unwindProtect
          (progn
            (putd '__abDrcCheckItem (lambda (_target) nil))
            (setq result (__abCheckDrcs "net" "GND" nil)))
          (putd '__abDrcCheckItem originalCheck))
        (qtest::assertNil result)))

    (qtest::TestCase test_drc_item_seam_runs_native_check
      (letseq ((design (__abFreshDesign))
               (target (car design->nets))
               (result (__abDrcCheckItem target)))
        (__abDrcUpdateDesign)
        (qtest::assertTrue (or (null result) (listp result)))))

    (qtest::TestCase test_drc_item_rejects_missing_stable_key
      (let (result failureText)
        (setq result (errset (__abCheckDrcs "component" "__MISSING__" nil)))
        (setq failureText (sprintf nil "%L" errset.errset))
        (qtest::assertTrue
          (and (null result)
               (index failureText "DRC_TARGET_NOT_FOUND")))))

    (qtest::TestCase test_drc_update_projects_and_restores_control
      (let ((originalUpdate (getd '__abDrcUpdateDesign))
            (originalEnable (axlDBControl 'drcEnable))
            result restored)
        (unwindProtect
          (progn
            (axlDBControl 'drcEnable nil)
            (putd '__abDrcUpdateDesign
                  (lambda ()
                    (axlDBControl 'drcEnable t)
                    7))
            (setq result (__abUpdateDrcs))
            (setq restored (axlDBControl 'drcEnable)))
          (progn
            (putd '__abDrcUpdateDesign originalUpdate)
            (axlDBControl 'drcEnable originalEnable)))
        (qtest::assertTrue (and result (null restored)))))

    (qtest::TestCase test_drc_update_seam_runs_design_check
      (let ((updated (__abDrcUpdateDesign)))
        (qtest::assertEqual (axlDRCGetCount) updated)))

    (qtest::TestCase test_drc_update_error_restores_control
      (let ((originalUpdate (getd '__abDrcUpdateDesign))
            (originalEnable (axlDBControl 'drcEnable))
            result failureText restored)
        (unwindProtect
          (progn
            (axlDBControl 'drcEnable nil)
            (putd '__abDrcUpdateDesign
                  (lambda ()
                    (axlDBControl 'drcEnable t)
                    (error "DRC_UPDATE_FAILED")))
            (setq result (errset (__abUpdateDrcs)))
            (setq failureText (sprintf nil "%L" errset.errset))
            (setq restored (axlDBControl 'drcEnable)))
          (progn
            (putd '__abDrcUpdateDesign originalUpdate)
            (axlDBControl 'drcEnable originalEnable)))
        (qtest::assertTrue
          (and (null result)
               (null restored)
               (index failureText "DRC_UPDATE_FAILED")))))

    (qtest::TestCase test_drc_projection_error_restores_control
      (let ((originalUpdate (getd '__abDrcUpdateDesign))
            (originalProject (getd '__abProjectDrcs))
            (originalEnable (axlDBControl 'drcEnable))
            result failureText restored)
        (unwindProtect
          (progn
            (axlDBControl 'drcEnable nil)
            (putd '__abDrcUpdateDesign
                  (lambda ()
                    (axlDBControl 'drcEnable t)
                    7))
            (putd '__abProjectDrcs (lambda () (error "DRC_PROJECT_FAILED")))
            (setq result (errset (__abUpdateDrcs)))
            (setq failureText (sprintf nil "%L" errset.errset))
            (setq restored (axlDBControl 'drcEnable)))
          (progn
            (putd '__abDrcUpdateDesign originalUpdate)
            (putd '__abProjectDrcs originalProject)
            (axlDBControl 'drcEnable originalEnable)))
        (qtest::assertTrue
          (and (null result)
               (null restored)
               (index failureText "DRC_PROJECT_FAILED")))))))
