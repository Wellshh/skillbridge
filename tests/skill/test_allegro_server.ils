;;; Copyright (c) 2025-2026 Bai Junyan and contributors.
;;; SPDX-License-Identifier: LGPL-3.0-or-later
;;; test_allegro_server.ils - Unit tests for the Allegro transaction kernel.

(qcover::load (strcat (qub::scriptDir)
                      "/../../allegrobridge/server/allegro_server.il"))

(defun __abTestRunTransaction (okValue startValue commitValue rollbackValue command)
  (let ((originalOK (getd '__abOKToProceed))
        (originalStart (getd '__abTransactionStart))
        (originalCommit (getd '__abTransactionCommit))
        (originalRollback (getd '__abTransactionRollback))
        calls
        result
        failure)
    (unwindProtect
      (progn
        (putd '__abOKToProceed
              (lambda ()
                (setq calls (cons 'ok calls))
                okValue))
        (putd '__abTransactionStart
              (lambda ()
                (setq calls (cons 'start calls))
                startValue))
        (putd '__abTransactionCommit
              (lambda (mark)
                (setq calls (cons (list 'commit mark) calls))
                commitValue))
        (putd '__abTransactionRollback
              (lambda (mark)
                (setq calls (cons (list 'rollback mark) calls))
                ;; Deliberately overwrite errset.errset.  The transaction
                ;; kernel must already have saved the command failure.
                (errset (plus 1 "rollback-overwrite"))
                rollbackValue))
        (setq result (errset (__abRunTransaction command)))
        (unless result
          (setq failure errset.errset)))
      (progn
        (putd '__abOKToProceed originalOK)
        (putd '__abTransactionStart originalStart)
        (putd '__abTransactionCommit originalCommit)
        (putd '__abTransactionRollback originalRollback)))
    (list result
          failure
          (reverse calls)
          (and (eq originalOK (getd '__abOKToProceed))
               (eq originalStart (getd '__abTransactionStart))
               (eq originalCommit (getd '__abTransactionCommit))
               (eq originalRollback (getd '__abTransactionRollback))))))

(defun __abTestRunOperation (operation okValue startValues commitValues rollbackValues)
  (let ((originalOK (getd '__abOKToProceed))
        (originalStart (getd '__abTransactionStart))
        (originalCommit (getd '__abTransactionCommit))
        (originalRollback (getd '__abTransactionRollback))
        calls
        result
        failure)
    (unwindProtect
      (progn
        (putd '__abOKToProceed
              (lambda ()
                (setq calls (cons 'ok calls))
                okValue))
        (putd '__abTransactionStart
              (lambda ()
                (let ((value (car startValues)))
                  (setq startValues (cdr startValues))
                  (setq calls (cons 'start calls))
                  value)))
        (putd '__abTransactionCommit
              (lambda (mark)
                (let ((value (car commitValues)))
                  (setq commitValues (cdr commitValues))
                  (setq calls (cons (list 'commit mark) calls))
                  value)))
        (putd '__abTransactionRollback
              (lambda (mark)
                (let ((value (car rollbackValues)))
                  (setq rollbackValues (cdr rollbackValues))
                  (setq calls (cons (list 'rollback mark) calls))
                  (errset (plus 1 "rollback-overwrite"))
                  value)))
        (setq result (errset (funcall operation)))
        (unless result
          (setq failure errset.errset)))
      (progn
        (putd '__abOKToProceed originalOK)
        (putd '__abTransactionStart originalStart)
        (putd '__abTransactionCommit originalCommit)
        (putd '__abTransactionRollback originalRollback)))
    (list result
          failure
          (reverse calls)
          (and (eq originalOK (getd '__abOKToProceed))
               (eq originalStart (getd '__abTransactionStart))
               (eq originalCommit (getd '__abTransactionCommit))
               (eq originalRollback (getd '__abTransactionRollback))))))

(defun __abTestMoveOperation (design transformValue refreshValue refdes x y rotation)
  (let ((originalFreshDesign (getd '__abFreshDesign))
        (originalRefreshSymbol (getd '__abRefreshSymbol))
        (originalTransformSymbol (getd '__abTransformSymbol))
        observed
        result
        success)
    (unwindProtect
      (progn
        (putd '__abFreshDesign (lambda () design))
        (putd '__abRefreshSymbol
              (lambda (symbol)
                (when refreshValue symbol)))
        (putd '__abTransformSymbol
              (lambda (symbol delta angle)
                (setq observed (list delta angle))
                transformValue))
        (catch t
          (setq result (__abMoveComponent refdes x y rotation))
          (setq success t)))
      (progn
        (putd '__abFreshDesign originalFreshDesign)
        (putd '__abRefreshSymbol originalRefreshSymbol)
        (putd '__abTransformSymbol originalTransformSymbol)))
    (list success result observed)))

(defun __abTestMoveByOperation (design refreshedDesign transformValue refdeses dx dy)
  (let ((originalFreshDesign (getd '__abFreshDesign))
        (originalTransformSymbols (getd '__abTransformSymbols))
        (designs (list design refreshedDesign))
        observed
        (transformCount 0)
        (freshCount 0)
        result
        success)
    (unwindProtect
      (progn
        (putd '__abFreshDesign
              (lambda ()
                (let ((value (car designs)))
                  (setq designs (cdr designs))
                  (setq freshCount (add1 freshCount))
                  value)))
        (putd '__abTransformSymbols
              (lambda (symbols delta)
                (setq transformCount (add1 transformCount))
                (setq observed (list symbols delta))
                transformValue))
        (catch t
          (setq result (__abMoveComponentsBy refdeses dx dy))
          (setq success t)))
      (progn
        (putd '__abFreshDesign originalFreshDesign)
        (putd '__abTransformSymbols originalTransformSymbols)))
    (list success result observed transformCount freshCount)))

(qtest::runSuites
  (qtest::TestSuite ()
    (qtest::TestCase test_move_rejects_missing_component
      (letseq ((otherComponent (list nil 'name "OTHER" 'symbol nil))
               (design (list nil 'components (list otherComponent)))
               (run (__abTestMoveOperation design t t "__MISSING_COMPONENT__"
                                            1.0 2.0 nil)))
        (qtest::assertNil (car run))
        (qtest::assertNil (caddr run))))

    (qtest::TestCase test_move_rejects_unplaced_component
      (letseq ((component (list nil 'name "R2" 'symbol nil))
               (design (list nil 'components (list component)))
               (run (__abTestMoveOperation design t t "R2" 1.0 2.0 nil)))
        (qtest::assertNil (car run))
        (qtest::assertNil (caddr run))))

    (qtest::TestCase test_move_reports_transform_failure
      (letseq ((symbol (list nil 'xy 1.0:2.0 'rotation 90.0))
               (component (list nil 'name "R3" 'symbol symbol))
               (design (list nil 'components (list component)))
               (run (__abTestMoveOperation design nil t "R3" 1.0 2.0 nil)))
        (qtest::assertNil (car run))
        (qtest::assertTrue (caddr run))))

    (qtest::TestCase test_move_reports_refresh_failure
      (letseq ((symbol (list nil 'xy 1.0:2.0 'rotation 90.0))
               (component (list nil 'name "R4" 'symbol symbol))
               (design (list nil 'components (list component)))
               (run (__abTestMoveOperation design t nil "R4" 1.0 2.0 nil)))
        (qtest::assertNil (car run))
        (qtest::assertTrue (caddr run))))

    (qtest::TestCase test_move_by_transforms_all_symbols_once_and_preserves_order
      (letseq ((symbol1 (list nil 'xy 1.0:2.0 'rotation 0.0))
               (symbol2 (list nil 'xy 3.0:4.0 'rotation 90.0))
               (component1 (list nil 'name "R1" 'deviceType "RESISTOR"
                                 'package "RES_0402" 'class "DISCRETE"
                                 'symbol symbol1))
               (component2 (list nil 'name "R2" 'deviceType "RESISTOR"
                                 'package "RES_0402" 'class "DISCRETE"
                                 'symbol symbol2))
               (design (list nil 'components (list component1 component2)))
               (run (__abTestMoveByOperation design design t '("R2" "R1") 1.0 2.0)))
        (qtest::assertTrue (car run))
        (qtest::assertEqual
          '("R2" "R1")
          (mapcar (lambda (component) (get component 'refdes)) (cadr run)))
        (qtest::assertEqual (list symbol2 symbol1) (car (caddr run)))
        (qtest::assertEqual '(1.0 2.0) (cadr (caddr run)))
        (qtest::assertEqual 1 (cadddr run))
        (qtest::assertEqual 2 (car (cddddr run)))))

    (qtest::TestCase test_move_by_empty_input_returns_without_transform
      (letseq ((design (list nil 'components nil))
               (run (__abTestMoveByOperation design design t nil 1.0 2.0)))
        (qtest::assertTrue (car run))
        (qtest::assertNil (cadr run))
        (qtest::assertNil (caddr run))
        (qtest::assertEqual 0 (cadddr run))
        (qtest::assertEqual 1 (car (cddddr run)))))

    (qtest::TestCase test_move_by_validates_all_components_before_transform
      (letseq ((symbol (list nil 'xy 1.0:2.0 'rotation 0.0))
               (placed (list nil 'name "R1" 'symbol symbol))
               (unplaced (list nil 'name "R2" 'symbol nil))
               (design (list nil 'components (list placed unplaced)))
               (missing (__abTestMoveByOperation design design t '("R1" "MISSING")
                                                 1.0 2.0))
               (notPlaced (__abTestMoveByOperation design design t '("R1" "R2")
                                                   1.0 2.0)))
        (qtest::assertNil (car missing))
        (qtest::assertEqual 0 (cadddr missing))
        (qtest::assertNil (car notPlaced))
        (qtest::assertEqual 0 (cadddr notPlaced))))

    (qtest::TestCase test_move_by_reports_transform_and_refresh_failures
      (letseq ((symbol (list nil 'xy 1.0:2.0 'rotation 0.0))
               (component (list nil 'name "R1" 'symbol symbol))
               (design (list nil 'components (list component)))
               (missingAfter (list nil 'components nil))
               (transformFailure
                 (__abTestMoveByOperation design design nil '("R1") 1.0 2.0))
               (refreshFailure
                 (__abTestMoveByOperation design missingAfter t '("R1") 1.0 2.0)))
        (qtest::assertNil (car transformFailure))
        (qtest::assertEqual 1 (cadddr transformFailure))
        (qtest::assertEqual 1 (car (cddddr transformFailure)))
        (qtest::assertNil (car refreshFailure))
        (qtest::assertEqual 1 (cadddr refreshFailure))
        (qtest::assertEqual 2 (car (cddddr refreshFailure)))))

    (qtest::TestCase test_components_projection_filters_refdes_and_placement
      (letseq ((originalFreshDesign (getd '__abFreshDesign))
               (symbol (list nil 'xy 1.0:2.0 'rotation 0.0))
               (placed (list nil 'name "R1" 'deviceType "RESISTOR"
                             'package "RES_0402" 'class "DISCRETE"
                             'symbol symbol))
               (unplaced (list nil 'name "R2" 'deviceType "RESISTOR"
                               'package "RES_0402" 'class "DISCRETE"
                               'symbol nil))
               (design (list nil 'components (list placed unplaced)))
               allComponents placedComponents matched missing)
        (unwindProtect
          (progn
            (putd '__abFreshDesign (lambda () design))
            (setq allComponents (__abProjectComponents nil t))
            (setq placedComponents (__abProjectComponents nil nil))
            (setq matched (__abProjectComponents "R1" t))
            (setq missing (__abProjectComponents "__MISSING_COMPONENT__" t)))
          (putd '__abFreshDesign originalFreshDesign))
        (qtest::assertEqual 2 (length allComponents))
        (qtest::assertEqual 1 (length placedComponents))
        (qtest::assertEqual 1 (length matched))
        (qtest::assertNil missing)))

    )

  (qtest::TestSuite ()
    (qtest::TestCase test_projection_entrypoints_refresh_design
      (let ((originalFreshDesign (getd '__abFreshDesign))
            (design (list nil 'components nil 'symbols nil 'nets nil))
            (refreshCount 0))
        (unwindProtect
          (progn
            (putd '__abFreshDesign
                  (lambda ()
                    (setq refreshCount (add1 refreshCount))
                    design))
            (__abProjectBoard)
            (__abProjectComponents nil t)
            (__abProjectNets nil)
            (qtest::assertEqual 3 refreshCount))
          (putd '__abFreshDesign originalFreshDesign))))

    (qtest::TestCase test_board_projection_returns_stable_dpl
      (let ((board (__abProjectBoard))
            (design (axlDBGetDesign)))
        (qtest::assertTrue
          (and (stringp (get board 'path))
               (stringp (get board 'units))
               (equal (length design->components)
                      (get board 'component_count))
               (equal (length design->symbols)
                      (get board 'symbol_count))
               (equal (length design->nets)
                      (get board 'net_count)))))))

  (qtest::TestSuite ()
    (qtest::TestCase test_component_projection_has_explicit_placement
      (letseq ((symbol (list nil 'xy 1.0:2.0 'rotation 90.0))
               (component
                 (list nil
                       'name "R1"
                       'deviceType "RESISTOR"
                       'package "RES_0402"
                       'class "DISCRETE"
                       'symbol symbol))
               (placed (__abProjectComponent component))
               (unplaced
                 (__abProjectComponent
                   (list nil
                         'name "R2"
                         'deviceType "RESISTOR"
                         'package "RES_0402"
                         'class "DISCRETE"
                         'symbol nil))))
        (qtest::assertEqual "placed" (get placed 'placement))
        (qtest::assertEqual 1.0 (get placed 'x))
        (qtest::assertEqual 2.0 (get placed 'y))
        (qtest::assertEqual 90.0 (get placed 'rotation))
        (qtest::assertEqual "unplaced" (get unplaced 'placement))
        (qtest::assertNil (get unplaced 'x))
        (qtest::assertNil (get unplaced 'y))
        (qtest::assertNil (get unplaced 'rotation))))

    (qtest::TestCase test_move_finds_placed_component_and_uses_absolute_delta
      (letseq ((symbol (list nil 'xy 1.0:2.0 'rotation 90.0))
               (component
                 (list nil
                       'name "R1"
                       'deviceType "RESISTOR"
                       'package "RES_0402"
                       'class "DISCRETE"
                       'symbol symbol))
               (design (list nil 'components (list component)))
               (preserve (__abTestMoveOperation design t t "R1" 4.0 7.0 nil))
               (zero (__abTestMoveOperation design t t "R1" 4.0 7.0 0.0)))
        (qtest::assertTrue (car preserve))
        (qtest::assertEqual '(3.0 5.0) (car (caddr preserve)))
        (qtest::assertEqual 0.0 (cadr (caddr preserve)))
        (qtest::assertTrue (car zero))
        (qtest::assertEqual '(3.0 5.0) (car (caddr zero)))
        (qtest::assertEqual -90.0 (cadr (caddr zero))))))

  (qtest::TestSuite ()
    (qtest::TestCase test_net_projection_has_explicit_attributes
      (letseq ((net (list nil
                          'name "GND"
                          'nBranches 2
                          'unconnected 1
                          'unplaced 3
                          'dbid "db:1"))
               (projected (__abProjectNet net)))
        (qtest::assertTrue
          (and (equal "GND" (get projected 'name))
               (equal 2 (get projected 'branch_count))
               (equal 1 (get projected 'unconnected_count))
               (equal 3 (get projected 'unplaced_pin_count))
               (null (get projected 'dbid))))))

    (qtest::TestCase test_nets_projection_lists_and_finds_name
      (letseq ((design (axlDBGetDesign))
               (allNets (__abProjectNets nil)))
        (qtest::assertEqual (length design->nets) (length allNets))
        (when design->nets
          (letseq ((selected (car design->nets))
                   (name selected->name)
                   (matched (__abProjectNets name)))
            (qtest::assertEqual 1 (length matched))
            (qtest::assertEqual name (get (car matched) 'name))))
        (qtest::assertNil (__abProjectNets "__MISSING_NET__")))))

  (qtest::TestSuite ()
    (qtest::TestCase test_layer_projection_has_stable_attributes
      (letseq ((layer (list nil 'name "TOP" 'parentName "ETCH"
                            'number 1 'isEtch t 'dbid "db:1"))
               (projected (__abProjectLayer layer)))
        (qtest::assertEqual "ETCH/TOP" (get projected 'name))
        (qtest::assertEqual "ETCH" (get projected 'class_name))
        (qtest::assertEqual "TOP" (get projected 'subclass))
        (qtest::assertEqual 1 (get projected 'number))
        (qtest::assertNil (get projected 'dbid))))

    (qtest::TestCase test_layers_projection_filters_and_finds_name
      (let ((allLayers (__abProjectLayers nil nil))
            (etchLayers (__abProjectLayers nil t)))
        (qtest::assertTrue allLayers)
        (qtest::assertTrue etchLayers)
        (qtest::assertTrue (lessp (length etchLayers) (length allLayers)))
        (foreach layer etchLayers
          (qtest::assertEqual "ETCH" (get layer 'class_name)))
        (letseq ((selected (car etchLayers))
                 (matched (__abProjectLayers (get selected 'name) nil)))
          (qtest::assertEqual 1 (length matched))
          (qtest::assertEqual selected (car matched)))
        (qtest::assertNil (__abProjectLayers "ETCH/__MISSING_LAYER__" nil)))))

  (qtest::TestSuite ()
    (qtest::TestCase test_pin_projection_has_stable_placed_attributes
      (letseq ((net (list nil 'name "GND"))
               (pin (list nil 'number "1" 'name "PAD60CIR30D" 'net net
                          'xy 1.0:2.0 'rotation 90.0
                          'startEnd '("ETCH/TOP" "ETCH/BOTTOM") 'dbid "db:1"))
               (component (list nil 'name "U1" 'symbol t))
               (projected (__abProjectPin component pin)))
        (qtest::assertEqual "U1" (get projected 'refdes))
        (qtest::assertEqual "1" (get projected 'number))
        (qtest::assertEqual "GND" (get projected 'net))
        (qtest::assertEqual "PAD60CIR30D" (get projected 'padstack))
        (qtest::assertEqual "placed" (get projected 'placement))
        (qtest::assertEqual 1.0 (get projected 'x))
        (qtest::assertEqual 2.0 (get projected 'y))
        (qtest::assertEqual 90.0 (get projected 'rotation))
        (qtest::assertEqual "ETCH/TOP" (get projected 'start_layer))
        (qtest::assertEqual "ETCH/BOTTOM" (get projected 'end_layer))
        (qtest::assertNil (get projected 'dbid))))

    (qtest::TestCase test_pin_projection_handles_unplaced_and_dummy_net
      (letseq ((dummyNet (list nil 'name ""))
               (pin (list nil 'number "2" 'name nil 'net dummyNet))
               (directDummyPin (list nil 'number "3" 'name nil 'net ""))
               (component (list nil 'name "U2" 'symbol nil))
               (projected (__abProjectPin component pin))
               (directDummy (__abProjectPin component directDummyPin)))
        (qtest::assertEqual "unplaced" (get projected 'placement))
        (qtest::assertNil (get projected 'net))
        (qtest::assertNil (get directDummy 'net))
        (qtest::assertNil (get projected 'padstack))
        (qtest::assertNil (get projected 'x))
        (qtest::assertNil (get projected 'y))
        (qtest::assertNil (get projected 'rotation))
        (qtest::assertNil (get projected 'start_layer))
        (qtest::assertNil (get projected 'end_layer))))

    (qtest::TestCase test_pins_projection_filters_and_finds_stable_key
      (letseq ((allPins (__abProjectPins nil nil nil))
               (selected (car allPins))
               (refdes (get selected 'refdes))
               (number (get selected 'number))
               (byComponent (__abProjectPins refdes nil nil))
               (matched (__abProjectPins refdes number nil))
               netPin)
        (qtest::assertTrue allPins)
        (foreach pin byComponent
          (qtest::assertEqual refdes (get pin 'refdes)))
        (qtest::assertEqual 1 (length matched))
        (qtest::assertEqual selected (car matched))
        (foreach pin allPins
          (when (get pin 'net)
            (setq netPin pin)))
        (qtest::assertTrue netPin)
        (foreach pin (__abProjectPins nil nil (get netPin 'net))
          (qtest::assertEqual (get netPin 'net) (get pin 'net)))
        (qtest::assertNil (__abProjectPins "__MISSING_COMPONENT__" nil nil))
        (qtest::assertNil (__abProjectPins refdes "__MISSING_PIN__" nil))
        (qtest::assertNil (__abProjectPins nil nil "__MISSING_NET__")))))

  (qtest::TestSuite ()
    (qtest::TestCase test_padstack_projection_has_stable_attributes
      (letseq ((padstack (list nil 'name "VIA12" 'type "through"
                               'usage "through_via"
                               'startEnd '("TOP" "BOTTOM") 'dbid "db:1"))
               (projected (__abProjectPadstack padstack)))
        (qtest::assertEqual "VIA12" (get projected 'name))
        (qtest::assertEqual "through" (get projected 'type))
        (qtest::assertEqual "through_via" (get projected 'usage))
        (qtest::assertEqual "TOP" (get projected 'start_layer))
        (qtest::assertEqual "BOTTOM" (get projected 'end_layer))
        (qtest::assertNil (get projected 'dbid))))

    (qtest::TestCase test_padstack_projection_handles_missing_span
      (letseq ((padstack (list nil 'name "SMD" 'type "smd"
                               'usage "surface_pin" 'startEnd nil))
               (projected (__abProjectPadstack padstack)))
        (qtest::assertNil (get projected 'start_layer))
        (qtest::assertNil (get projected 'end_layer))))

    (qtest::TestCase test_padstacks_projection_lists_and_finds_name
      (letseq ((allPadstacks (__abProjectPadstacks nil))
               (selected (car allPadstacks))
               (name (get selected 'name))
               (matched (__abProjectPadstacks name)))
        (qtest::assertTrue allPadstacks)
        (qtest::assertEqual 1 (length matched))
        (qtest::assertEqual selected (car matched))
        (qtest::assertNil (__abProjectPadstacks "__MISSING_PADSTACK__")))))

  (qtest::TestSuite ()
    (qtest::TestCase test_symbol_projection_has_stable_attributes
      (letseq ((symbol (list nil 'name "RES_0402" 'type "PACKAGE"
                             'refdes "R1" 'xy '(1.0 2.0) 'rotation 90.0
                             'dbid "db:1"))
               (projected (__abProjectSymbol symbol)))
        (qtest::assertEqual "RES_0402" (get projected 'name))
        (qtest::assertEqual "PACKAGE" (get projected 'type))
        (qtest::assertEqual "R1" (get projected 'refdes))
        (qtest::assertEqual 1.0 (get projected 'x))
        (qtest::assertEqual 2.0 (get projected 'y))
        (qtest::assertEqual 90.0 (get projected 'rotation))
        (qtest::assertNil (get projected 'dbid))))

    (qtest::TestCase test_symbols_projection_lists_and_filters_type
      (letseq ((allSymbols (__abProjectSymbols nil))
               (selected (car allSymbols))
               (type (get selected 'type))
               (matched (__abProjectSymbols type)))
        (qtest::assertTrue allSymbols)
        (qtest::assertTrue matched)
        (foreach symbol matched
          (qtest::assertEqual type (get symbol 'type)))
        (qtest::assertNil (__abProjectSymbols "__MISSING_SYMBOL_TYPE__")))))

  (qtest::TestSuite ()
    (qtest::TestCase test_transaction_rejects_busy_allegro
      (letseq ((run (__abTestRunTransaction nil 17 t t "42"))
               (failureText (sprintf nil "%L" (cadr run))))
        (qtest::assertEqual '(ok) (nth 2 run)
                            ?msg "busy Allegro must not start a transaction")
        (qtest::assertTrue (index failureText "BUSY_ACTIVE_COMMAND"))))

    (qtest::TestCase test_transaction_rejects_failed_start
      (letseq ((run (__abTestRunTransaction t nil t t "42"))
               (failureText (sprintf nil "%L" (cadr run))))
        (qtest::assertEqual '(ok start) (nth 2 run)
                            ?msg "failed start must not commit or rollback")
        (qtest::assertTrue (index failureText "TRANSACTION_START_FAILED"))))

    (qtest::TestCase test_transaction_commits_non_nil_result
      (let ((run (__abTestRunTransaction t 17 t t "42")))
        (qtest::assertEqual '(42) (car run))
        (qtest::assertEqual '(ok start (commit 17)) (nth 2 run))))

    (qtest::TestCase test_transaction_commits_nil_result
      (let ((run (__abTestRunTransaction t 17 t t "nil")))
        (qtest::assertEqual '(nil) (car run)
                            ?msg "(nil) is a successful errsetstring result")
        (qtest::assertEqual '(ok start (commit 17)) (nth 2 run))))

    (qtest::TestCase test_transaction_rolls_back_parse_error
      (let (expectedError run failureText)
        (errsetstring "(")
        (setq expectedError (sprintf nil "%L" errset.errset))
        (setq run (__abTestRunTransaction t 17 t t "("))
        (setq failureText (sprintf nil "%L" (cadr run)))
        (qtest::assertEqual '(ok start (rollback 17)) (nth 2 run))
        (qtest::assertTrue
          (and (index failureText "TRANSACTION_COMMAND_FAILED")
               (index failureText expectedError))
          ?msg "parse failure must retain the original errset.errset")))

    (qtest::TestCase test_transaction_rolls_back_runtime_error
      (let (expectedError run failureText)
        (errsetstring "error(\"runtime-boom\")")
        (setq expectedError (sprintf nil "%L" errset.errset))
        (setq run
              (__abTestRunTransaction
                t 17 t t "error(\"runtime-boom\")"))
        (setq failureText (sprintf nil "%L" (cadr run)))
        (qtest::assertEqual '(ok start (rollback 17)) (nth 2 run))
        (qtest::assertTrue
          (and (index failureText "TRANSACTION_COMMAND_FAILED")
               (index failureText expectedError))
          ?msg "runtime failure must retain the original errset.errset"))))

  (qtest::TestSuite ()
    (qtest::TestCase test_command_and_rollback_failure_are_reported
      (letseq ((run
                 (__abTestRunTransaction
                   t 17 t nil "error(\"command-boom\")"))
               (failureText (sprintf nil "%L" (cadr run))))
        (qtest::assertEqual '(ok start (rollback 17)) (nth 2 run))
        (qtest::assertTrue
          (and (index failureText "TRANSACTION_COMMAND_FAILED")
               (index failureText "TRANSACTION_ROLLBACK_FAILED")))))

    (qtest::TestCase test_commit_failure_rolls_back
      (letseq ((run (__abTestRunTransaction t 17 nil t "42"))
               (failureText (sprintf nil "%L" (cadr run))))
        (qtest::assertEqual
          '(ok start (commit 17) (rollback 17))
          (nth 2 run)
          ?msg "commit failure must attempt exactly one rollback")
        (qtest::assertTrue (index failureText "TRANSACTION_COMMIT_FAILED"))
        (qtest::assertNil (index failureText "TRANSACTION_ROLLBACK_FAILED"))))

    (qtest::TestCase test_commit_and_rollback_failure_are_reported
      (letseq ((run (__abTestRunTransaction t 17 nil nil "42"))
               (failureText (sprintf nil "%L" (cadr run))))
        (qtest::assertEqual
          '(ok start (commit 17) (rollback 17))
          (nth 2 run))
        (qtest::assertTrue
          (and (index failureText "TRANSACTION_COMMIT_FAILED")
               (index failureText "TRANSACTION_ROLLBACK_FAILED")))))

    (qtest::TestCase test_transaction_mocks_are_restored
      (let ((run (__abTestRunTransaction t 17 t t "42")))
        (qtest::assertTrue (nth 3 run)
                           ?msg "all AXL wrappers must be restored"))))

  (qtest::TestSuite ()
    (qtest::TestCase test_savepoint_batch_rejects_busy_allegro
      (letseq ((run (__abTestRunOperation
                      (lambda () (__abRunSavepointBatch '("1")))
                      nil nil nil nil))
               (failureText (sprintf nil "%L" (cadr run))))
        (qtest::assertTrue
          (and (equal '(ok) (nth 2 run))
               (index failureText "BUSY_ACTIVE_COMMAND")))))

    (qtest::TestCase test_savepoint_batch_rejects_failed_outer_start
      (letseq ((run (__abTestRunOperation
                      (lambda () (__abRunSavepointBatch '("1")))
                      t '(nil) nil nil))
               (failureText (sprintf nil "%L" (cadr run))))
        (qtest::assertTrue
          (and (equal '(ok start) (nth 2 run))
               (index failureText "SAVEPOINT_BATCH_START_FAILED")))))

    (qtest::TestCase test_savepoint_batch_keeps_success_nil_and_failure_results
      (let (expectedError run results first second third fourth)
        (errsetstring "error(\"item-boom\")")
        (setq expectedError (sprintf nil "%L" errset.errset))
        (setq run
              (__abTestRunOperation
                (lambda ()
                  (__abRunSavepointBatch
                    '("11" "nil" "error(\"item-boom\")" "44")))
                t '(100 101 102 103 104) '(t t t t) '(t)))
        (setq results (car (car run)))
        (setq first (nth 0 results))
        (setq second (nth 1 results))
        (setq third (nth 2 results))
        (setq fourth (nth 3 results))
        (qtest::assertTrue
          (and (equal '(ok start start (commit 101)
                            start (commit 102)
                            start (rollback 103)
                            start (commit 104)
                            (commit 100))
                      (nth 2 run))
               (equal 0 (get first 'index))
               (equal "success" (get first 'status))
               (equal 11 (get first 'value))
               (equal 1 (get second 'index))
               (equal "success" (get second 'status))
               (null (get second 'value))
               (equal 2 (get third 'index))
               (equal "failure" (get third 'status))
               (index (get third 'error) "SAVEPOINT_COMMAND_FAILED")
               (index (get third 'error) expectedError)
               (equal 3 (get fourth 'index))
               (equal "success" (get fourth 'status))
               (equal 44 (get fourth 'value))))))

    (qtest::TestCase test_savepoint_batch_recovers_from_inner_commit_failure
      (letseq ((run (__abTestRunOperation
                      (lambda () (__abRunSavepointBatch '("11" "22")))
                      t '(100 101 102) '(nil t t) '(t)))
               (results (car (car run)))
               (failedItem (nth 0 results))
               (successfulItem (nth 1 results)))
        (qtest::assertTrue
          (and (equal '(ok start start (commit 101)
                            (rollback 101) start (commit 102)
                            (commit 100))
                      (nth 2 run))
               (equal "failure" (get failedItem 'status))
               (index (get failedItem 'error) "SAVEPOINT_COMMIT_FAILED")
               (equal "success" (get successfulItem 'status))
               (equal 22 (get successfulItem 'value))))))

    (qtest::TestCase test_savepoint_batch_aborts_when_inner_start_fails
      (letseq ((run (__abTestRunOperation
                      (lambda () (__abRunSavepointBatch '("11")))
                      t '(100 nil) nil '(t)))
               (failureText (sprintf nil "%L" (cadr run))))
        (qtest::assertTrue
          (and (equal '(ok start start (rollback 100)) (nth 2 run))
               (index failureText "SAVEPOINT_START_FAILED")))))

    (qtest::TestCase test_savepoint_batch_reports_abort_rollback_failure
      (letseq ((run (__abTestRunOperation
                      (lambda () (__abRunSavepointBatch '("11")))
                      t '(100 nil) nil '(nil)))
               (failureText (sprintf nil "%L" (cadr run))))
        (qtest::assertTrue
          (and (equal '(ok start start (rollback 100)) (nth 2 run))
               (index failureText "SAVEPOINT_START_FAILED")
               (index failureText "SAVEPOINT_BATCH_ROLLBACK_FAILED")))))

    (qtest::TestCase test_savepoint_batch_aborts_when_command_rollback_fails
      (let (expectedError run failureText)
        (errsetstring "error(\"item-boom\")")
        (setq expectedError (sprintf nil "%L" errset.errset))
        (setq run
              (__abTestRunOperation
                (lambda ()
                  (__abRunSavepointBatch '("error(\"item-boom\")")))
                t '(100 101) nil '(nil t)))
        (setq failureText (sprintf nil "%L" (cadr run)))
        (qtest::assertTrue
          (and (equal '(ok start start (rollback 101) (rollback 100))
                      (nth 2 run))
               (index failureText "SAVEPOINT_COMMAND_FAILED")
               (index failureText expectedError)
               (index failureText "SAVEPOINT_ROLLBACK_FAILED")))))

    (qtest::TestCase test_savepoint_batch_aborts_when_commit_rollback_fails
      (letseq ((run (__abTestRunOperation
                      (lambda () (__abRunSavepointBatch '("11")))
                      t '(100 101) '(nil) '(nil t)))
               (failureText (sprintf nil "%L" (cadr run))))
        (qtest::assertTrue
          (and (equal '(ok start start (commit 101)
                            (rollback 101) (rollback 100))
                      (nth 2 run))
               (index failureText "SAVEPOINT_COMMIT_FAILED")
               (index failureText "SAVEPOINT_ROLLBACK_FAILED")))))

    (qtest::TestCase test_savepoint_batch_rolls_back_failed_outer_commit
      (letseq ((run (__abTestRunOperation
                      (lambda () (__abRunSavepointBatch '("11")))
                      t '(100 101) '(t nil) '(t)))
               (failureText (sprintf nil "%L" (cadr run))))
        (qtest::assertTrue
          (and (equal '(ok start start (commit 101)
                            (commit 100) (rollback 100))
                      (nth 2 run))
               (index failureText "SAVEPOINT_BATCH_COMMIT_FAILED")
               (null (index failureText "SAVEPOINT_BATCH_ROLLBACK_FAILED"))))))

    (qtest::TestCase test_savepoint_batch_reports_failed_outer_rollback
      (letseq ((run (__abTestRunOperation
                      (lambda () (__abRunSavepointBatch '("11")))
                      t '(100 101) '(t nil) '(nil)))
               (failureText (sprintf nil "%L" (cadr run))))
        (qtest::assertTrue
          (and (equal '(ok start start (commit 101)
                            (commit 100) (rollback 100))
                      (nth 2 run))
               (index failureText "SAVEPOINT_BATCH_COMMIT_FAILED")
               (index failureText "SAVEPOINT_BATCH_ROLLBACK_FAILED"))))))

  (qtest::TestSuite ()
    (qtest::TestCase test_dry_run_rejects_busy_allegro
      (letseq ((run (__abTestRunOperation
                      (lambda () (__abRunDryTransaction "11"))
                      nil nil nil nil))
               (failureText (sprintf nil "%L" (cadr run))))
        (qtest::assertTrue
          (and (equal '(ok) (nth 2 run))
               (index failureText "BUSY_ACTIVE_COMMAND")))))

    (qtest::TestCase test_dry_run_rejects_failed_start
      (letseq ((run (__abTestRunOperation
                      (lambda () (__abRunDryTransaction "11"))
                      t '(nil) nil nil))
               (failureText (sprintf nil "%L" (cadr run))))
        (qtest::assertTrue
          (and (equal '(ok start) (nth 2 run))
               (index failureText "DRY_RUN_START_FAILED")))))

    (qtest::TestCase test_dry_run_returns_value_after_rollback
      (let ((run (__abTestRunOperation
                   (lambda () (__abRunDryTransaction "11"))
                   t '(100) nil '(t))))
        (qtest::assertEqual
          '((11) nil (ok start (rollback 100)) t)
          run)))

    (qtest::TestCase test_dry_run_accepts_nil_result
      (let ((run (__abTestRunOperation
                   (lambda () (__abRunDryTransaction "nil"))
                   t '(100) nil '(t))))
        (qtest::assertEqual
          '((nil) nil (ok start (rollback 100)) t)
          run)))

    (qtest::TestCase test_dry_run_preserves_command_error_before_rollback
      (let (expectedError run failureText)
        (errsetstring "error(\"dry-boom\")")
        (setq expectedError (sprintf nil "%L" errset.errset))
        (setq run
              (__abTestRunOperation
                (lambda () (__abRunDryTransaction "error(\"dry-boom\")"))
                t '(100) nil '(t)))
        (setq failureText (sprintf nil "%L" (cadr run)))
        (qtest::assertTrue
          (and (equal '(ok start (rollback 100)) (nth 2 run))
               (index failureText "DRY_RUN_COMMAND_FAILED")
               (index failureText expectedError)))))

    (qtest::TestCase test_dry_run_does_not_return_value_when_rollback_fails
      (letseq ((run (__abTestRunOperation
                      (lambda () (__abRunDryTransaction "11"))
                      t '(100) nil '(nil)))
               (failureText (sprintf nil "%L" (cadr run))))
        (qtest::assertTrue
          (and (null (car run))
               (equal '(ok start (rollback 100)) (nth 2 run))
               (index failureText "DRY_RUN_ROLLBACK_FAILED")))))

    (qtest::TestCase test_dry_run_reports_command_and_rollback_failure
      (let (expectedError run failureText)
        (errsetstring "error(\"dry-boom\")")
        (setq expectedError (sprintf nil "%L" errset.errset))
        (setq run
              (__abTestRunOperation
                (lambda () (__abRunDryTransaction "error(\"dry-boom\")"))
                t '(100) nil '(nil)))
        (setq failureText (sprintf nil "%L" (cadr run)))
        (qtest::assertTrue
          (and (equal '(ok start (rollback 100)) (nth 2 run))
               (index failureText "DRY_RUN_COMMAND_FAILED")
               (index failureText expectedError)
               (index failureText "DRY_RUN_ROLLBACK_FAILED")
               (nth 3 run)))))))
