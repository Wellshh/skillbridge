;;; test_allegro_server.ils - Unit tests for the Allegro transaction kernel.

(qcover::load (strcat (qub::scriptDir)
                      "/../../allegrobridge/server/allegro_server.il"))

(defun __abTestRunTransaction (okValue startValue commitValue rollbackValue command)
  (let ((originalOK (getd '__abOKToProceed))
        (originalStart (getd '__abTransactionStart))
        (originalCommit (getd '__abTransactionCommit))
        (originalRollback (getd '__abTransactionRollback))
        calls
        result
        failure)
    (unwindProtect
      (progn
        (putd '__abOKToProceed
              (lambda ()
                (setq calls (cons 'ok calls))
                okValue))
        (putd '__abTransactionStart
              (lambda ()
                (setq calls (cons 'start calls))
                startValue))
        (putd '__abTransactionCommit
              (lambda (mark)
                (setq calls (cons (list 'commit mark) calls))
                commitValue))
        (putd '__abTransactionRollback
              (lambda (mark)
                (setq calls (cons (list 'rollback mark) calls))
                ;; Deliberately overwrite errset.errset.  The transaction
                ;; kernel must already have saved the command failure.
                (errset (plus 1 "rollback-overwrite"))
                rollbackValue))
        (setq result (errset (__abRunTransaction command)))
        (unless result
          (setq failure errset.errset)))
      (progn
        (putd '__abOKToProceed originalOK)
        (putd '__abTransactionStart originalStart)
        (putd '__abTransactionCommit originalCommit)
        (putd '__abTransactionRollback originalRollback)))
    (list result
          failure
          (reverse calls)
          (and (eq originalOK (getd '__abOKToProceed))
               (eq originalStart (getd '__abTransactionStart))
               (eq originalCommit (getd '__abTransactionCommit))
               (eq originalRollback (getd '__abTransactionRollback))))))

(defun __abTestRunOperation (operation okValue startValues commitValues rollbackValues)
  (let ((originalOK (getd '__abOKToProceed))
        (originalStart (getd '__abTransactionStart))
        (originalCommit (getd '__abTransactionCommit))
        (originalRollback (getd '__abTransactionRollback))
        calls
        result
        failure)
    (unwindProtect
      (progn
        (putd '__abOKToProceed
              (lambda ()
                (setq calls (cons 'ok calls))
                okValue))
        (putd '__abTransactionStart
              (lambda ()
                (let ((value (car startValues)))
                  (setq startValues (cdr startValues))
                  (setq calls (cons 'start calls))
                  value)))
        (putd '__abTransactionCommit
              (lambda (mark)
                (let ((value (car commitValues)))
                  (setq commitValues (cdr commitValues))
                  (setq calls (cons (list 'commit mark) calls))
                  value)))
        (putd '__abTransactionRollback
              (lambda (mark)
                (let ((value (car rollbackValues)))
                  (setq rollbackValues (cdr rollbackValues))
                  (setq calls (cons (list 'rollback mark) calls))
                  (errset (plus 1 "rollback-overwrite"))
                  value)))
        (setq result (errset (funcall operation)))
        (unless result
          (setq failure errset.errset)))
      (progn
        (putd '__abOKToProceed originalOK)
        (putd '__abTransactionStart originalStart)
        (putd '__abTransactionCommit originalCommit)
        (putd '__abTransactionRollback originalRollback)))
    (list result
          failure
          (reverse calls)
          (and (eq originalOK (getd '__abOKToProceed))
               (eq originalStart (getd '__abTransactionStart))
               (eq originalCommit (getd '__abTransactionCommit))
               (eq originalRollback (getd '__abTransactionRollback))))))

(defun __abTestMoveOperation (design transformValue refreshValue refdes x y rotation)
  (let ((originalGetDesign (getd 'axlDBGetDesign))
        (originalRefreshId (getd 'axlDBRefreshId))
        (originalTransform (getd 'axlTransformObject))
        oldDebugMode
        observed
        result
        failure)
    (setq oldDebugMode (status debugMode))
    (unwindProtect
      (progn
        (sstatus debugMode t)
        (putd 'axlDBGetDesign (lambda () design))
        (putd 'axlDBRefreshId
              (lambda (dbid)
                (when refreshValue dbid)))
        (putd 'axlTransformObject
              (lambda (dbid @key (move nil) (angle nil))
                (setq observed (list move angle))
                transformValue))
        (setq result
              (errset
                (__abMoveComponentUnsafe refdes x y rotation)))
        (unless result
          (setq failure errset.errset)))
      (progn
        (putd 'axlDBGetDesign originalGetDesign)
        (putd 'axlDBRefreshId originalRefreshId)
        (putd 'axlTransformObject originalTransform)
        (sstatus debugMode oldDebugMode)))
    (list result failure observed)))

(qtest::runSuites
  (qtest::TestSuite ()
    (qtest::TestCase test_projection_entrypoints_refresh_design
      (let ((originalFreshDesign (getd '__abFreshDesign))
            (design (list nil 'components nil 'symbols nil 'nets nil))
            (refreshCount 0))
        (unwindProtect
          (progn
            (putd '__abFreshDesign
                  (lambda ()
                    (setq refreshCount (add1 refreshCount))
                    design))
            (__abProjectBoard)
            (__abProjectComponents nil t)
            (__abProjectNets nil)
            (qtest::assertEqual 3 refreshCount))
          (putd '__abFreshDesign originalFreshDesign))))

    (qtest::TestCase test_board_projection_returns_stable_dpl
      (let ((board (__abProjectBoard))
            (design (axlDBGetDesign)))
        (qtest::assertTrue
          (and (stringp (get board 'path))
               (stringp (get board 'units))
               (equal (length design->components)
                      (get board 'component_count))
               (equal (length design->symbols)
                      (get board 'symbol_count))
               (equal (length design->nets)
                      (get board 'net_count)))))))

  (qtest::TestSuite ()
    (qtest::TestCase test_component_projection_has_explicit_placement
      (letseq ((symbol (list nil 'xy 1.0:2.0 'rotation 90.0))
               (component
                 (list nil
                       'name "R1"
                       'deviceType "RESISTOR"
                       'package "RES_0402"
                       'class "DISCRETE"
                       'symbol symbol))
               (placed (__abProjectComponent component))
               (unplaced
                 (__abProjectComponent
                   (list nil
                         'name "R2"
                         'deviceType "RESISTOR"
                         'package "RES_0402"
                         'class "DISCRETE"
                         'symbol nil))))
        (qtest::assertEqual "placed" (get placed 'placement))
        (qtest::assertEqual 1.0 (get placed 'x))
        (qtest::assertEqual 2.0 (get placed 'y))
        (qtest::assertEqual 90.0 (get placed 'rotation))
        (qtest::assertEqual "unplaced" (get unplaced 'placement))
        (qtest::assertNil (get unplaced 'x))
        (qtest::assertNil (get unplaced 'y))
        (qtest::assertNil (get unplaced 'rotation))))

    (qtest::TestCase test_move_finds_placed_component_and_uses_absolute_delta
      (letseq ((symbol (list nil 'xy 1.0:2.0 'rotation 90.0))
               (component
                 (list nil
                       'name "R1"
                       'deviceType "RESISTOR"
                       'package "RES_0402"
                       'class "DISCRETE"
                       'symbol symbol))
               (design (list nil 'components (list component)))
               (preserve (__abTestMoveOperation design t t "R1" 4.0 7.0 nil))
               (zero (__abTestMoveOperation design t t "R1" 4.0 7.0 0.0)))
        (qtest::assertTrue (car preserve))
        (qtest::assertEqual '(3.0 5.0) (car(caddr preserve)))
        (qtest::assertEqual 0.0 (cadr(caddr preserve)))
        (qtest::assertTrue (car zero))
        (qtest::assertEqual '(3.0 5.0) (car(caddr zero)))
        (qtest::assertEqual -90.0 (cadr(caddr zero))))))

    (qtest::TestCase test_move_rejects_missing_component
      (letseq ((otherComponent (list nil 'name "OTHER" 'symbol nil))
               (design (list nil 'components (list otherComponent)))
               (run (__abTestMoveOperation design t t "__MISSING_COMPONENT__"
                                            1.0 2.0 nil))
               (failureText (sprintf nil "%L" (cadr run))))
        (qtest::assertNil (car run))
        (qtest::assertTrue (index failureText "COMPONENT_NOT_FOUND"))))

    (qtest::TestCase test_move_rejects_unplaced_component
      (letseq ((component
                 (list nil
                       'name "R2"
                       'deviceType "RESISTOR"
                       'package "RES_0402"
                       'class "DISCRETE"
                       'symbol nil))
               (design (list nil 'components (list component)))
               (run (__abTestMoveOperation design t t "R2" 1.0 2.0 nil))
               (failureText (sprintf nil "%L" (cadr run))))
        (qtest::assertNil (car run))
        (qtest::assertTrue (index failureText "COMPONENT_UNPLACED"))))

    (qtest::TestCase test_move_reports_transform_failure
      (letseq ((symbol (list nil 'xy 1.0:2.0 'rotation 90.0))
               (component
                 (list nil
                       'name "R3"
                       'deviceType "RESISTOR"
                       'package "RES_0402"
                       'class "DISCRETE"
                       'symbol symbol))
               (design (list nil 'components (list component)))
               (run (__abTestMoveOperation design nil t "R3" 1.0 2.0 nil))
               (failureText (sprintf nil "%L" (cadr run))))
        (qtest::assertNil (car run))
        (qtest::assertTrue (index failureText "COMPONENT_TRANSFORM_FAILED"))))

    (qtest::TestCase test_move_reports_refresh_failure
      (letseq ((symbol (list nil 'xy 1.0:2.0 'rotation 90.0))
               (component
                 (list nil
                       'name "R4"
                       'deviceType "RESISTOR"
                       'package "RES_0402"
                       'class "DISCRETE"
                       'symbol symbol))
               (design (list nil 'components (list component)))
               (run (__abTestMoveOperation design t nil "R4" 1.0 2.0 nil))
               (failureText (sprintf nil "%L" (cadr run))))
        (qtest::assertNil (car run))
        (qtest::assertTrue (index failureText "COMPONENT_REFRESH_FAILED"))))

    (qtest::TestCase test_move_public_procedure_delegates_to_transaction
      (let ((originalRun (getd '__abRunTransaction))
            (command)
            result)
        (unwindProtect
          (progn
            (putd '__abRunTransaction
                  (lambda (commandText)
                    (setq command commandText)
                    'delegated))
            (setq result (__abMoveComponent "R4" 1.0 2.0 nil)))
          (putd '__abRunTransaction originalRun))
        (qtest::assertEqual 'delegated result)
        (qtest::assertEqual
          "(__abMoveComponentUnsafe \"R4\" 1.0 2.0 nil)"
          command)))

    (qtest::TestCase test_components_projection_filters_and_finds_refdes
      (letseq ((design (axlDBGetDesign))
               (allComponents (__abProjectComponents nil t))
               (placedComponents (__abProjectComponents nil nil))
               (allPlaced t))
        (foreach component placedComponents
          (unless (equal "placed" (get component 'placement))
            (setq allPlaced nil)))
        (qtest::assertEqual (length design->components)
                            (length allComponents))
        (qtest::assertTrue allPlaced)
        (when design->components
          (letseq ((selected (car design->components))
                   (refdes selected->name)
                   (matched (__abProjectComponents refdes t)))
            (qtest::assertEqual 1 (length matched))
            (qtest::assertEqual refdes (get (car matched) 'refdes))))
        (qtest::assertNil
          (__abProjectComponents "__MISSING_COMPONENT__" t)))))

  (qtest::TestSuite ()
    (qtest::TestCase test_net_projection_has_explicit_attributes
      (letseq ((net (list nil
                          'name "GND"
                          'nBranches 2
                          'unconnected 1
                          'unplaced 3
                          'dbid "db:1"))
               (projected (__abProjectNet net)))
        (qtest::assertTrue
          (and (equal "GND" (get projected 'name))
               (equal 2 (get projected 'branch_count))
               (equal 1 (get projected 'unconnected_count))
               (equal 3 (get projected 'unplaced_pin_count))
               (null (get projected 'dbid))))))

    (qtest::TestCase test_nets_projection_lists_and_finds_name
      (letseq ((design (axlDBGetDesign))
               (allNets (__abProjectNets nil)))
        (qtest::assertEqual (length design->nets) (length allNets))
        (when design->nets
          (letseq ((selected (car design->nets))
                   (name selected->name)
                   (matched (__abProjectNets name)))
            (qtest::assertEqual 1 (length matched))
            (qtest::assertEqual name (get (car matched) 'name))))
        (qtest::assertNil (__abProjectNets "__MISSING_NET__")))))

  (qtest::TestSuite ()
    (qtest::TestCase test_transaction_rejects_busy_allegro
      (letseq ((run (__abTestRunTransaction nil 17 t t "42"))
               (failureText (sprintf nil "%L" (cadr run))))
        (qtest::assertEqual '(ok) (nth 2 run)
                            ?msg "busy Allegro must not start a transaction")
        (qtest::assertTrue (index failureText "BUSY_ACTIVE_COMMAND"))))

    (qtest::TestCase test_transaction_rejects_failed_start
      (letseq ((run (__abTestRunTransaction t nil t t "42"))
               (failureText (sprintf nil "%L" (cadr run))))
        (qtest::assertEqual '(ok start) (nth 2 run)
                            ?msg "failed start must not commit or rollback")
        (qtest::assertTrue (index failureText "TRANSACTION_START_FAILED"))))

    (qtest::TestCase test_transaction_commits_non_nil_result
      (let ((run (__abTestRunTransaction t 17 t t "42")))
        (qtest::assertEqual '(42) (car run))
        (qtest::assertEqual '(ok start (commit 17)) (nth 2 run))))

    (qtest::TestCase test_transaction_commits_nil_result
      (let ((run (__abTestRunTransaction t 17 t t "nil")))
        (qtest::assertEqual '(nil) (car run)
                            ?msg "(nil) is a successful errsetstring result")
        (qtest::assertEqual '(ok start (commit 17)) (nth 2 run))))

    (qtest::TestCase test_transaction_rolls_back_parse_error
      (let (expectedError run failureText)
        (errsetstring "(")
        (setq expectedError (sprintf nil "%L" errset.errset))
        (setq run (__abTestRunTransaction t 17 t t "("))
        (setq failureText (sprintf nil "%L" (cadr run)))
        (qtest::assertEqual '(ok start (rollback 17)) (nth 2 run))
        (qtest::assertTrue
          (and (index failureText "TRANSACTION_COMMAND_FAILED")
               (index failureText expectedError))
          ?msg "parse failure must retain the original errset.errset")))

    (qtest::TestCase test_transaction_rolls_back_runtime_error
      (let (expectedError run failureText)
        (errsetstring "error(\"runtime-boom\")")
        (setq expectedError (sprintf nil "%L" errset.errset))
        (setq run
              (__abTestRunTransaction
                t 17 t t "error(\"runtime-boom\")"))
        (setq failureText (sprintf nil "%L" (cadr run)))
        (qtest::assertEqual '(ok start (rollback 17)) (nth 2 run))
        (qtest::assertTrue
          (and (index failureText "TRANSACTION_COMMAND_FAILED")
               (index failureText expectedError))
          ?msg "runtime failure must retain the original errset.errset"))))

  (qtest::TestSuite ()
    (qtest::TestCase test_command_and_rollback_failure_are_reported
      (letseq ((run
                 (__abTestRunTransaction
                   t 17 t nil "error(\"command-boom\")"))
               (failureText (sprintf nil "%L" (cadr run))))
        (qtest::assertEqual '(ok start (rollback 17)) (nth 2 run))
        (qtest::assertTrue
          (and (index failureText "TRANSACTION_COMMAND_FAILED")
               (index failureText "TRANSACTION_ROLLBACK_FAILED")))))

    (qtest::TestCase test_commit_failure_rolls_back
      (letseq ((run (__abTestRunTransaction t 17 nil t "42"))
               (failureText (sprintf nil "%L" (cadr run))))
        (qtest::assertEqual
          '(ok start (commit 17) (rollback 17))
          (nth 2 run)
          ?msg "commit failure must attempt exactly one rollback")
        (qtest::assertTrue (index failureText "TRANSACTION_COMMIT_FAILED"))
        (qtest::assertNil (index failureText "TRANSACTION_ROLLBACK_FAILED"))))

    (qtest::TestCase test_commit_and_rollback_failure_are_reported
      (letseq ((run (__abTestRunTransaction t 17 nil nil "42"))
               (failureText (sprintf nil "%L" (cadr run))))
        (qtest::assertEqual
          '(ok start (commit 17) (rollback 17))
          (nth 2 run))
        (qtest::assertTrue
          (and (index failureText "TRANSACTION_COMMIT_FAILED")
               (index failureText "TRANSACTION_ROLLBACK_FAILED")))))

    (qtest::TestCase test_transaction_mocks_are_restored
      (let ((run (__abTestRunTransaction t 17 t t "42")))
        (qtest::assertTrue (nth 3 run)
                           ?msg "all AXL wrappers must be restored"))))

  (qtest::TestSuite ()
    (qtest::TestCase test_savepoint_batch_rejects_busy_allegro
      (letseq ((run (__abTestRunOperation
                      (lambda () (__abRunSavepointBatch '("1")))
                      nil nil nil nil))
               (failureText (sprintf nil "%L" (cadr run))))
        (qtest::assertTrue
          (and (equal '(ok) (nth 2 run))
               (index failureText "BUSY_ACTIVE_COMMAND")))))

    (qtest::TestCase test_savepoint_batch_rejects_failed_outer_start
      (letseq ((run (__abTestRunOperation
                      (lambda () (__abRunSavepointBatch '("1")))
                      t '(nil) nil nil))
               (failureText (sprintf nil "%L" (cadr run))))
        (qtest::assertTrue
          (and (equal '(ok start) (nth 2 run))
               (index failureText "SAVEPOINT_BATCH_START_FAILED")))))

    (qtest::TestCase test_savepoint_batch_keeps_success_nil_and_failure_results
      (let (expectedError run results first second third fourth)
        (errsetstring "error(\"item-boom\")")
        (setq expectedError (sprintf nil "%L" errset.errset))
        (setq run
              (__abTestRunOperation
                (lambda ()
                  (__abRunSavepointBatch
                    '("11" "nil" "error(\"item-boom\")" "44")))
                t '(100 101 102 103 104) '(t t t t) '(t)))
        (setq results (car (car run)))
        (setq first (nth 0 results))
        (setq second (nth 1 results))
        (setq third (nth 2 results))
        (setq fourth (nth 3 results))
        (qtest::assertTrue
          (and (equal '(ok start start (commit 101)
                            start (commit 102)
                            start (rollback 103)
                            start (commit 104)
                            (commit 100))
                      (nth 2 run))
               (equal 0 (get first 'index))
               (equal "success" (get first 'status))
               (equal 11 (get first 'value))
               (equal 1 (get second 'index))
               (equal "success" (get second 'status))
               (null (get second 'value))
               (equal 2 (get third 'index))
               (equal "failure" (get third 'status))
               (index (get third 'error) "SAVEPOINT_COMMAND_FAILED")
               (index (get third 'error) expectedError)
               (equal 3 (get fourth 'index))
               (equal "success" (get fourth 'status))
               (equal 44 (get fourth 'value))))))

    (qtest::TestCase test_savepoint_batch_recovers_from_inner_commit_failure
      (letseq ((run (__abTestRunOperation
                      (lambda () (__abRunSavepointBatch '("11" "22")))
                      t '(100 101 102) '(nil t t) '(t)))
               (results (car (car run)))
               (failedItem (nth 0 results))
               (successfulItem (nth 1 results)))
        (qtest::assertTrue
          (and (equal '(ok start start (commit 101)
                            (rollback 101) start (commit 102)
                            (commit 100))
                      (nth 2 run))
               (equal "failure" (get failedItem 'status))
               (index (get failedItem 'error) "SAVEPOINT_COMMIT_FAILED")
               (equal "success" (get successfulItem 'status))
               (equal 22 (get successfulItem 'value))))))

    (qtest::TestCase test_savepoint_batch_aborts_when_inner_start_fails
      (letseq ((run (__abTestRunOperation
                      (lambda () (__abRunSavepointBatch '("11")))
                      t '(100 nil) nil '(t)))
               (failureText (sprintf nil "%L" (cadr run))))
        (qtest::assertTrue
          (and (equal '(ok start start (rollback 100)) (nth 2 run))
               (index failureText "SAVEPOINT_START_FAILED")))))

    (qtest::TestCase test_savepoint_batch_reports_abort_rollback_failure
      (letseq ((run (__abTestRunOperation
                      (lambda () (__abRunSavepointBatch '("11")))
                      t '(100 nil) nil '(nil)))
               (failureText (sprintf nil "%L" (cadr run))))
        (qtest::assertTrue
          (and (equal '(ok start start (rollback 100)) (nth 2 run))
               (index failureText "SAVEPOINT_START_FAILED")
               (index failureText "SAVEPOINT_BATCH_ROLLBACK_FAILED")))))

    (qtest::TestCase test_savepoint_batch_aborts_when_command_rollback_fails
      (let (expectedError run failureText)
        (errsetstring "error(\"item-boom\")")
        (setq expectedError (sprintf nil "%L" errset.errset))
        (setq run
              (__abTestRunOperation
                (lambda ()
                  (__abRunSavepointBatch '("error(\"item-boom\")")))
                t '(100 101) nil '(nil t)))
        (setq failureText (sprintf nil "%L" (cadr run)))
        (qtest::assertTrue
          (and (equal '(ok start start (rollback 101) (rollback 100))
                      (nth 2 run))
               (index failureText "SAVEPOINT_COMMAND_FAILED")
               (index failureText expectedError)
               (index failureText "SAVEPOINT_ROLLBACK_FAILED")))))

    (qtest::TestCase test_savepoint_batch_aborts_when_commit_rollback_fails
      (letseq ((run (__abTestRunOperation
                      (lambda () (__abRunSavepointBatch '("11")))
                      t '(100 101) '(nil) '(nil t)))
               (failureText (sprintf nil "%L" (cadr run))))
        (qtest::assertTrue
          (and (equal '(ok start start (commit 101)
                            (rollback 101) (rollback 100))
                      (nth 2 run))
               (index failureText "SAVEPOINT_COMMIT_FAILED")
               (index failureText "SAVEPOINT_ROLLBACK_FAILED")))))

    (qtest::TestCase test_savepoint_batch_rolls_back_failed_outer_commit
      (letseq ((run (__abTestRunOperation
                      (lambda () (__abRunSavepointBatch '("11")))
                      t '(100 101) '(t nil) '(t)))
               (failureText (sprintf nil "%L" (cadr run))))
        (qtest::assertTrue
          (and (equal '(ok start start (commit 101)
                            (commit 100) (rollback 100))
                      (nth 2 run))
               (index failureText "SAVEPOINT_BATCH_COMMIT_FAILED")
               (null (index failureText "SAVEPOINT_BATCH_ROLLBACK_FAILED"))))))

    (qtest::TestCase test_savepoint_batch_reports_failed_outer_rollback
      (letseq ((run (__abTestRunOperation
                      (lambda () (__abRunSavepointBatch '("11")))
                      t '(100 101) '(t nil) '(nil)))
               (failureText (sprintf nil "%L" (cadr run))))
        (qtest::assertTrue
          (and (equal '(ok start start (commit 101)
                            (commit 100) (rollback 100))
                      (nth 2 run))
               (index failureText "SAVEPOINT_BATCH_COMMIT_FAILED")
               (index failureText "SAVEPOINT_BATCH_ROLLBACK_FAILED"))))))

  (qtest::TestSuite ()
    (qtest::TestCase test_dry_run_rejects_busy_allegro
      (letseq ((run (__abTestRunOperation
                      (lambda () (__abRunDryTransaction "11"))
                      nil nil nil nil))
               (failureText (sprintf nil "%L" (cadr run))))
        (qtest::assertTrue
          (and (equal '(ok) (nth 2 run))
               (index failureText "BUSY_ACTIVE_COMMAND")))))

    (qtest::TestCase test_dry_run_rejects_failed_start
      (letseq ((run (__abTestRunOperation
                      (lambda () (__abRunDryTransaction "11"))
                      t '(nil) nil nil))
               (failureText (sprintf nil "%L" (cadr run))))
        (qtest::assertTrue
          (and (equal '(ok start) (nth 2 run))
               (index failureText "DRY_RUN_START_FAILED")))))

    (qtest::TestCase test_dry_run_returns_value_after_rollback
      (let ((run (__abTestRunOperation
                   (lambda () (__abRunDryTransaction "11"))
                   t '(100) nil '(t))))
        (qtest::assertEqual
          '((11) nil (ok start (rollback 100)) t)
          run)))

    (qtest::TestCase test_dry_run_accepts_nil_result
      (let ((run (__abTestRunOperation
                   (lambda () (__abRunDryTransaction "nil"))
                   t '(100) nil '(t))))
        (qtest::assertEqual
          '((nil) nil (ok start (rollback 100)) t)
          run)))

    (qtest::TestCase test_dry_run_preserves_command_error_before_rollback
      (let (expectedError run failureText)
        (errsetstring "error(\"dry-boom\")")
        (setq expectedError (sprintf nil "%L" errset.errset))
        (setq run
              (__abTestRunOperation
                (lambda () (__abRunDryTransaction "error(\"dry-boom\")"))
                t '(100) nil '(t)))
        (setq failureText (sprintf nil "%L" (cadr run)))
        (qtest::assertTrue
          (and (equal '(ok start (rollback 100)) (nth 2 run))
               (index failureText "DRY_RUN_COMMAND_FAILED")
               (index failureText expectedError)))))

    (qtest::TestCase test_dry_run_does_not_return_value_when_rollback_fails
      (letseq ((run (__abTestRunOperation
                      (lambda () (__abRunDryTransaction "11"))
                      t '(100) nil '(nil)))
               (failureText (sprintf nil "%L" (cadr run))))
        (qtest::assertTrue
          (and (null (car run))
               (equal '(ok start (rollback 100)) (nth 2 run))
               (index failureText "DRY_RUN_ROLLBACK_FAILED")))))

    (qtest::TestCase test_dry_run_reports_command_and_rollback_failure
      (let (expectedError run failureText)
        (errsetstring "error(\"dry-boom\")")
        (setq expectedError (sprintf nil "%L" errset.errset))
        (setq run
              (__abTestRunOperation
                (lambda () (__abRunDryTransaction "error(\"dry-boom\")"))
                t '(100) nil '(nil)))
        (setq failureText (sprintf nil "%L" (cadr run)))
        (qtest::assertTrue
          (and (equal '(ok start (rollback 100)) (nth 2 run))
               (index failureText "DRY_RUN_COMMAND_FAILED")
               (index failureText expectedError)
               (index failureText "DRY_RUN_ROLLBACK_FAILED")
               (nth 3 run)))))))
