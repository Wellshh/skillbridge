(defun qtest:::assert (test
                       quoted_inputs
                       evaluated_inputs
                       @key (msg "No msg."))
  (if test
      (qtest:::makeResult 'Pass msg quoted_inputs evaluated_inputs)
      (qtest:::makeResult 'Fail msg quoted_inputs evaluated_inputs)))

(defmacro qtest:::assertEqual (a b @key (msg "No msg."))
  (let ((x (gensym))
        (y (gensym)))
    `(letseq ((,x ,a)
           (,y ,b))
       (qtest:::assert (qub::equal ,x ,y)
                       (list ',a ',b)
                       (list ,x ,y)
                       ?msg ,msg))))

(defmacro qtest:::assertNotEqual (a b @key (msg "No msg."))
  (let ((x (gensym))
        (y (gensym)))
    `(letseq ((,x ,a)
           (,y ,b))
       (qtest:::assert (qub::nequal ,x ,y)
                       (list ',a ',b)
                       (list ,x ,y)
                       ?msg ,msg))))

(defmacro qtest:::assertTrue (x @key (msg "No msg."))
  (let ((value (gensym)))
    `(letseq ((,value ,x))
       (qtest:::assert (not (null ,value))
                       (list ',x)
                       (list ,value)
                       ?msg ,msg))))

(defmacro qtest:::assertNil (x @key (msg "No msg."))
  (let ((value (gensym)))
    `(letseq ((,value ,x))
       (qtest:::assert (null ,value)
                       (list ',x)
                       (list ,value)
                       ?msg ,msg))))

(defmacro qtest:::assertEq (a b @key (msg "No msg."))
  (let ((x (gensym))
        (y (gensym)))
    `(letseq ((,x ,a)
           (,y ,b))
       (qtest:::assert (eq ,x ,y)
                       (list ',a ',b)
                       (list ,x ,y)
                       ?msg ,msg))))

(defmacro qtest:::assertNotEq (a b @key (msg "No msg."))
  (let ((x (gensym))
        (y (gensym)))
    `(letseq ((,x ,a)
           (,y ,b))
       (qtest:::assert (neq ,x ,y)
                       (list ',a ',b)
                       (list ,x ,y)
                       ?msg ,msg))))

(defmacro qtest:::assertMember (value lst @key (msg "No msg."))
  (let ((x (gensym))
        (y (gensym)))
    `(letseq ((,x ,value)
           (,y ,lst))
       (qtest:::assert (member ,x ,y)
                       (list ',value ',lst)
                       (list ,x ,y)
                       ?msg ,msg))))

(defmacro qtest:::assertNotMember (value lst @key (msg "No msg."))
  (let ((x (gensym))
        (y (gensym)))
    `(letseq ((,x ,value)
           (,y ,lst))
       (qtest:::assert (not (member ,x ,y))
                       (list ',value ',lst)
                       (list ,x ,y)
                       ?msg ,msg))))

(defmacro qtest:::assertIsInstance (obj cls @key (msg "No msg."))
  (let ((x (gensym))
        (y (gensym)))
    `(letseq ((,x ,obj)
           (,y ,cls))
       (qtest:::assert (classp ,x (findClass ,y))
                       (list ',obj ',cls)
                       (list ,x ,y)
                       ?msg ,msg))))

(defmacro qtest:::assertNotIsInstance (obj cls @key (msg "No msg."))
  (let ((x (gensym))
        (y (gensym)))
    `(letseq ((,x ,obj)
           (,y ,cls))
       (qtest:::assert (not (classp ,x (findClass ,y)))
                       (list ',obj ',cls)
                       (list ,x ,y)
                       ?msg ,msg))))

(defmacro qtest:::raised (fn)
  (let ((raised (gensym)))
    `(letseq ((,raised t))
       (catch t
         ,fn
         (setq ,raised nil))
       ,raised)))

(defmacro qtest:::assertRaises (fn @key (msg "No msg."))
  `(qtest:::assert (qtest:::raised ,fn)
                   (list ',fn)
                   (list "Can't include it as it's meant to fail")
                   ?msg ,msg))

(defmacro qtest:::assertAlmostEqual (a b @key (rel_tol 0) (abs_tol 0) (msg "No msg"))
  (let ((x (gensym))
        (y (gensym))
        (rel (gensym))
        (abs (gensym)))
    `(letseq ((,x ,a)
           (,y ,b)
           (,rel ,rel_tol)
           (,abs ,abs_tol))
       (qtest:::assert
         (qub::almostEqual ,x ,y ?rel_tol ,rel ?abs_tol ,abs)
         (list ',a ',b ',rel_tol ',abs_tol)
         (list ,x ,y ,rel ,abs)
         ?msg ,msg))))

(defmacro qtest:::assertNotAlmostEqual (a b @key (rel_tol 0) (abs_tol 0) (msg "No msg"))
  (let ((x (gensym))
        (y (gensym))
        (rel (gensym))
        (abs (gensym)))
    `(letseq ((,x ,a)
           (,y ,b)
           (,rel ,rel_tol)
           (,abs ,abs_tol))
       (qtest:::assert
         (qub::notAlmostEqual ,x ,y ?rel_tol ,rel ?abs_tol ,abs)
         (list ',a ',b ',rel_tol ',abs_tol)
         (list ,x ,y ,rel ,abs)
         ?msg ,msg))))
