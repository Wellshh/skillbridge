;;; Copyright (c) 2025-2026 Bai Junyan and contributors.
;;; SPDX-License-Identifier: LGPL-3.0-or-later
;;; test_qcover.ils - Regression tests for classic SKILL branch coverage.

(letseq ((_fixtureDir (strcat (qub::scriptDir) "/fixtures"))
         (_fixture (strcat _fixtureDir "/branches.il"))
         (_lexicalFixture (strcat _fixtureDir "/lexical.ils"))
         (_multipleFixture (strcat _fixtureDir "/lexical_multiple.ils"))
         (_invalidLexicalFixture (strcat _fixtureDir "/invalid_lexical.ils"))
         (_invalidFixture (strcat _fixtureDir "/invalid.il"))
         (_originalLexicalFixtureCall (getd 'qcoverIlsFixtureCall))
         (_originalMultipleCall (getd 'qcoverIlsMultipleCall))
         (_originalMultipleCount (getd 'qcoverIlsMultipleCount))
         (_originalMultipleQuoted (getd 'qcoverIlsMultipleQuoted))
         (_originalInvalidCall (getd 'qcoverIlsInvalidCall))
         (_qcoverTemps
           (lambda (directory)
             (setof file
                    (getDirFiles directory)
                    (qub::startsWith (qub::getFileName file) ".qcover-"))))
         (_setDifference
           (lambda (left right)
             (setof item left (not (member item right)))))
         (_normalizedMultipleFixture
           (qub::normalizePath (simplifyFilename _multipleFixture))))
  (unwindProtect
    (qtest::runSuites
      (qtest::TestSuite ()
      (qtest::TestCase test_linereadstring_wraps_one_function_form
        (qtest::assertEq
          'procedure
          (caar (linereadstring "procedure(qcoverParseFixture(value) value)"))
          ?msg "qcover expects linereadstring's outer logical-line result list"))

      (qtest::TestCase test_load_restores_runtime_state
        (let ((debugModeBefore (status debugMode))
              (openFilesBefore (numOpenFiles)))
          (qcover::reset)
          (qcover::load _fixture)
          (qtest::assertEqual
            (list debugModeBefore openFilesBefore)
            (list (status debugMode) (numOpenFiles))
            ?msg "qcover::load must restore debugMode and close temporary ports")))

      (qtest::TestCase test_load_failure_restores_debug_mode
        (letseq ((debugModeBefore (status debugMode))
                 (loadResult
                   (qtest::assertRaises (qcover::load _invalidFixture))))
          (qtest::assertEqual
            (list 'Pass debugModeBefore)
            (list (get_result loadResult) (status debugMode))
            ?msg "Malformed load must fail and restore debugMode"))))

      (qtest::TestSuite ()
      (qtest::TestCase test_report_threshold_fails_for_missing_branch
        (qcover::reset)
        (qcover::load _fixture)
        (qcoverFixtureIf t)
        (qtest::assertRaises (qcover::report ?minimum 100.0)
                             ?msg "Incomplete coverage must fail an explicit threshold"))

      (qtest::TestCase test_report_identifies_missing_branch
        (qcover::reset)
        (qcover::load _fixture)
        (qcoverFixtureIf t)
        (let ((port (outstring))
              report
              percentage)
          (unwindProtect
            (progn
              (setq percentage (qcover::report ?port port))
              (setq report (getOutstring port)))
            (close port))
          (qtest::assertTrue
            (and (greaterp percentage 0.0)
                 (lessp percentage 100.0)
                 (index report "qcoverFixtureIf#1")
                 (index report "false")
                 (index report "value"))
            ?msg "Partial report must include percentage and missing branch metadata")))

      (qtest::TestCase test_reset_clears_coverage
        (qcover::reset)
        (qtest::assertEqual '(0 0) (qcover:::coverageCounts)
                            ?msg "reset must clear covered and total branch counts")))

      (qtest::TestSuite ()
      (qtest::TestCase test_all_condition_outcomes_reach_full_coverage
        (qcover::reset)
        (qcover::load _fixture)
        (qtest::assertEqual '(0 18) (qcover:::coverageCounts)
                            ?msg "fixture must register exactly nine decisions")

        (qtest::assertEqual 'yes (qcoverFixtureIf t))
        (qtest::assertEqual 'no (qcoverFixtureIf nil))
        (qtest::assertEqual 'yes (qcoverFixtureIfNoElse t))
        (qtest::assertNil (qcoverFixtureIfNoElse nil))

        (qtest::assertEqual 'yes (qcoverFixtureWhen t))
        (qtest::assertNil (qcoverFixtureWhen nil))
        (qtest::assertNil (qcoverFixtureUnless t))
        (qtest::assertEqual 'yes (qcoverFixtureUnless nil))

        (qtest::assertEqual 'one (qcoverFixtureCond 1))
        (qtest::assertEqual 'two (qcoverFixtureCond 2))
        (qtest::assertEqual 'other (qcoverFixtureCond 3))

        (qtest::assertEqual 'both (qcoverFixtureNested t t))
        (qtest::assertEqual 'first (qcoverFixtureNested t nil))
        (qtest::assertEqual 'none (qcoverFixtureNested nil t))

        (set 'qcoverFixtureSideEffects 0)
        (qtest::assertEqual 'first (qcoverFixtureOnce))
        (qtest::assertEqual 'later (qcoverFixtureOnce))
        (qtest::assertEqual 2 (symeval 'qcoverFixtureSideEffects)
                            ?msg "instrumented conditions must execute exactly once")

        (qtest::assertEqual (symeval 'qcoverFixtureQuotedExpected)
                            (qcoverFixtureQuoted)
                            ?msg "quoted branch-shaped data must not be instrumented")
        (qtest::assertEqual 100.0 (qcover::report ?minimum 100.0)
                            ?msg "all executable condition outcomes must be covered")))

    (qtest::TestSuite ()
      (qtest::TestCase test_ils_lexical_fixture_qualification
        (qcover::reset)
        (qcover::load _lexicalFixture)
        (qtest::assertEqual '(0 2) (qcover:::coverageCounts)
                            ?msg "lexical closure must register exactly one decision before execution")
        (qtest::assertEqual 'yes (qcoverIlsFixtureCall t))
        (qtest::assertEqual 'no (qcoverIlsFixtureCall nil))
        (qtest::assertEqual '(2 2) (qcover:::coverageCounts))
        (qtest::assertEqual 100.0 (qcover::report ?minimum 100.0)
                            ?msg "lexical .ils fixture must reach full coverage")))
    (qtest::TestSuite ()
      (qtest::TestCase test_ils_multiple_forms_only_cover_callable_bodies
        (qcover::reset)
        (qcover::load _multipleFixture)
        (qtest::assertEqual '(0 2) (qcover:::coverageCounts))
        (qtest::assertEqual '(if(t then 'yes else 'no))
                            (qcoverIlsMultipleQuoted))
        (qtest::assertEqual 0 (qcoverIlsMultipleCount)))

      (qtest::TestCase test_ils_multiple_condition_runs_once
        (qcover::reset)
        (qcover::load _multipleFixture)
        (qtest::assertEqual '(0 2) (qcover:::coverageCounts))
        (qtest::assertEqual 'yes (qcoverIlsMultipleCall t))
        (qtest::assertEqual 'no (qcoverIlsMultipleCall nil))
        (qtest::assertEqual 2 (qcoverIlsMultipleCount))
        (qtest::assertEqual '(2 2) (qcover:::coverageCounts)))

      (let ((before nil)
            (debugModeBefore nil)
            (openFilesBefore nil)
            (after nil)
            (created nil)
            (report nil)
            (port nil))
        (qtest::TestCase test_ils_owned_temp_and_original_report_identity
          (qcover::reset)
          (setq before (_qcoverTemps (car (axlDMFileParts _multipleFixture))))
          (setq debugModeBefore (status debugMode))
          (setq openFilesBefore (numOpenFiles))
          (qcover::load _multipleFixture)
          (setq after (_qcoverTemps (car (axlDMFileParts _multipleFixture))))
          (setq created (_setDifference after before))
          (qtest::assertEqual 1 (length created))
          (setq port (outstring))
          (unwindProtect
            (progn
              (qcoverIlsMultipleCall t)
              (qcover::report ?port port)
              (setq report (getOutstring port)))
            (close port))
          (qtest::assertNil (_setDifference before after))
          (qtest::assertTrue
            (and (qub::startsWith (qub::getFileName (car created)) ".qcover-")
                 (equal (rindex (qub::getFileName (car created)) ".ils") ".ils")
                 (index report _normalizedMultipleFixture)
                 (not (index report ".qcover-"))))
          (qtest::assertEqual debugModeBefore (status debugMode))
          (qtest::assertEqual openFilesBefore (numOpenFiles))))

      (let ((sentinel nil)
            (priorTemps nil)
            (priorCall nil)
            (priorCounts nil)
            (debugModeBefore nil)
            (openFilesBefore nil)
            (result nil))
        (qtest::TestCase test_ils_failure_is_atomic
          (qcover::reset)
          (qcover::load _multipleFixture)
          (setq priorCall (getd 'qcoverIlsMultipleCall))
          (setq priorCounts (qcover:::coverageCounts))
          (setq priorTemps (_qcoverTemps (car (axlDMFileParts _multipleFixture))))
          (setq debugModeBefore (status debugMode))
          (setq openFilesBefore (numOpenFiles))
          (qtest::assertEqual '(0 2) priorCounts)
          (setq sentinel (lambda () 'sentinel))
          (putd 'qcoverIlsInvalidCall sentinel)
          (setq result (qtest::assertRaises (qcover::load _invalidLexicalFixture)))
          (qtest::assertEq 'Pass (get_result result))
          (qtest::assertEq sentinel (getd 'qcoverIlsInvalidCall))
          (qtest::assertEq priorCall (getd 'qcoverIlsMultipleCall))
          (qtest::assertEqual priorCounts (qcover:::coverageCounts))
          (qtest::assertEqual '(0 2) (qcover:::coverageCounts))
          (qtest::assertNil (_setDifference priorTemps (_qcoverTemps (car (axlDMFileParts _invalidLexicalFixture)))))
          (qtest::assertNil (_setDifference (_qcoverTemps (car (axlDMFileParts _invalidLexicalFixture))) priorTemps))
          (qtest::assertEqual debugModeBefore (status debugMode))
          (qtest::assertEqual openFilesBefore (numOpenFiles))))

      (let ((sentinel nil)
            (directory nil)
            (before nil)
            (after nil)
            (secondBefore nil)
            (secondAfter nil))
        (qtest::TestCase test_ils_reset_restores_slot_and_temp
          (qcover::reset)
          (setq directory (car (axlDMFileParts _multipleFixture)))
          (setq sentinel (lambda (value) 'sentinel))
          (putd 'qcoverIlsMultipleCall sentinel)
          (setq before (_qcoverTemps directory))
          (qcover::load _multipleFixture)
          (setq after (_qcoverTemps directory))
          (qtest::assertEqual 1 (length (_setDifference after before)))
          (qtest::assertNil (_setDifference before after))
          (qcover::reset)
          (qtest::assertEq sentinel (getd 'qcoverIlsMultipleCall))
          (qtest::assertNil (_setDifference before (_qcoverTemps directory)))
          (qtest::assertNil (_setDifference (_qcoverTemps directory) before))
          (qtest::assertEqual '(0 0) (qcover:::coverageCounts))
          (setq secondBefore (_qcoverTemps directory))
          (qcover::load _multipleFixture)
          (setq secondAfter (_qcoverTemps directory))
          (qtest::assertEqual 1 (length (_setDifference secondAfter secondBefore)))
          (qtest::assertNil (_setDifference secondBefore secondAfter))
          (qcoverIlsMultipleCall t)
          (qcoverIlsMultipleCall nil)
          (qtest::assertEqual '(2 2) (qcover:::coverageCounts))
          (qcover::reset)
          (qtest::assertEq sentinel (getd 'qcoverIlsMultipleCall))
          (qtest::assertNil (_setDifference before (_qcoverTemps directory)))
          (qtest::assertNil (_setDifference (_qcoverTemps directory) before))
          (qtest::assertEqual '(0 0) (qcover:::coverageCounts))))

      (let ((directory nil)
            (before nil)
            (after nil))
        (qtest::TestCase test_ils_cumulative_sources
          (qcover::reset)
          (setq directory (car (axlDMFileParts _multipleFixture)))
          (setq before (_qcoverTemps directory))
          (qcover::load _lexicalFixture)
          (qcover::load _multipleFixture)
          (qtest::assertEqual '(0 4) (qcover:::coverageCounts))
          (setq after (_qcoverTemps directory))
          (qtest::assertEqual 2 (length (_setDifference after before)))
          (qtest::assertNil (_setDifference before after))
          (qcoverIlsFixtureCall t)
          (qcoverIlsFixtureCall nil)
          (qcoverIlsMultipleCall t)
          (qcoverIlsMultipleCall nil)
          (qtest::assertEqual '(4 4) (qcover:::coverageCounts))))))

    (unwindProtect
      (qcover::reset)
      (progn
        (putd 'qcoverIlsFixtureCall _originalLexicalFixtureCall)
        (putd 'qcoverIlsMultipleCall _originalMultipleCall)
        (putd 'qcoverIlsMultipleCount _originalMultipleCount)
        (putd 'qcoverIlsMultipleQuoted _originalMultipleQuoted)
        (putd 'qcoverIlsInvalidCall _originalInvalidCall)))))
