;;; Copyright (c) 2025-2026 Bai Junyan and contributors.
;;; SPDX-License-Identifier: LGPL-3.0-or-later
;;; test_qcover.ils - Regression tests for classic SKILL branch coverage.

(letseq ((_fixtureDir (strcat (qub::scriptDir) "/fixtures"))
         (_fixture (strcat _fixtureDir "/branches.il"))
         (_lexicalFixture (strcat _fixtureDir "/lexical.ils"))
         (_invalidFixture (strcat _fixtureDir "/invalid.il"))
         (_originalLexicalFixtureCall (getd 'qcoverIlsFixtureCall)))
  (unwindProtect
    (qtest::runSuites
      (qtest::TestSuite ()
      (qtest::TestCase test_linereadstring_wraps_one_function_form
        (qtest::assertEq
          'procedure
          (caar (linereadstring "procedure(qcoverParseFixture(value) value)"))
          ?msg "qcover expects linereadstring's outer logical-line result list"))

      (qtest::TestCase test_load_restores_runtime_state
        (let ((debugModeBefore (status debugMode))
              (openFilesBefore (numOpenFiles)))
          (qcover::reset)
          (qcover::load _fixture)
          (qtest::assertEqual
            (list debugModeBefore openFilesBefore)
            (list (status debugMode) (numOpenFiles))
            ?msg "qcover::load must restore debugMode and close temporary ports")))

      (qtest::TestCase test_load_failure_restores_debug_mode
        (letseq ((debugModeBefore (status debugMode))
                 (loadResult
                   (qtest::assertRaises (qcover::load _invalidFixture))))
          (qtest::assertEqual
            (list 'Pass debugModeBefore)
            (list (get_result loadResult) (status debugMode))
            ?msg "Malformed load must fail and restore debugMode"))))

      (qtest::TestSuite ()
      (qtest::TestCase test_report_threshold_fails_for_missing_branch
        (qcover::reset)
        (qcover::load _fixture)
        (qcoverFixtureIf t)
        (qtest::assertRaises (qcover::report ?minimum 100.0)
                             ?msg "Incomplete coverage must fail an explicit threshold"))

      (qtest::TestCase test_report_identifies_missing_branch
        (qcover::reset)
        (qcover::load _fixture)
        (qcoverFixtureIf t)
        (let ((port (outstring))
              report
              percentage)
          (unwindProtect
            (progn
              (setq percentage (qcover::report ?port port))
              (setq report (getOutstring port)))
            (close port))
          (qtest::assertTrue
            (and (greaterp percentage 0.0)
                 (lessp percentage 100.0)
                 (index report "qcoverFixtureIf#1")
                 (index report "false")
                 (index report "value"))
            ?msg "Partial report must include percentage and missing branch metadata")))

      (qtest::TestCase test_reset_clears_coverage
        (qcover::reset)
        (qtest::assertEqual '(0 0) (qcover:::coverageCounts)
                            ?msg "reset must clear covered and total branch counts")))

      (qtest::TestSuite ()
      (qtest::TestCase test_all_condition_outcomes_reach_full_coverage
        (qcover::reset)
        (qcover::load _fixture)
        (qtest::assertEqual '(0 18) (qcover:::coverageCounts)
                            ?msg "fixture must register exactly nine decisions")

        (qtest::assertEqual 'yes (qcoverFixtureIf t))
        (qtest::assertEqual 'no (qcoverFixtureIf nil))
        (qtest::assertEqual 'yes (qcoverFixtureIfNoElse t))
        (qtest::assertNil (qcoverFixtureIfNoElse nil))

        (qtest::assertEqual 'yes (qcoverFixtureWhen t))
        (qtest::assertNil (qcoverFixtureWhen nil))
        (qtest::assertNil (qcoverFixtureUnless t))
        (qtest::assertEqual 'yes (qcoverFixtureUnless nil))

        (qtest::assertEqual 'one (qcoverFixtureCond 1))
        (qtest::assertEqual 'two (qcoverFixtureCond 2))
        (qtest::assertEqual 'other (qcoverFixtureCond 3))

        (qtest::assertEqual 'both (qcoverFixtureNested t t))
        (qtest::assertEqual 'first (qcoverFixtureNested t nil))
        (qtest::assertEqual 'none (qcoverFixtureNested nil t))

        (set 'qcoverFixtureSideEffects 0)
        (qtest::assertEqual 'first (qcoverFixtureOnce))
        (qtest::assertEqual 'later (qcoverFixtureOnce))
        (qtest::assertEqual 2 (symeval 'qcoverFixtureSideEffects)
                            ?msg "instrumented conditions must execute exactly once")

        (qtest::assertEqual (symeval 'qcoverFixtureQuotedExpected)
                            (qcoverFixtureQuoted)
                            ?msg "quoted branch-shaped data must not be instrumented")
        (qtest::assertEqual 100.0 (qcover::report ?minimum 100.0)
                            ?msg "all executable condition outcomes must be covered")))

    (qtest::TestSuite ()
      (qtest::TestCase test_ils_lexical_fixture_qualification
        (qcover::reset)
        (qcover::load _lexicalFixture)
        (qtest::assertEqual '(0 2) (qcover:::coverageCounts)
                            ?msg "lexical closure must register exactly one decision before execution")
        (qtest::assertEqual 'yes (qcoverIlsFixtureCall t))
        (qtest::assertEqual 'no (qcoverIlsFixtureCall nil))
        (qtest::assertEqual '(2 2) (qcover:::coverageCounts))
        (qtest::assertEqual 100.0 (qcover::report ?minimum 100.0)
                            ?msg "lexical .ils fixture must reach full coverage"))))
    (progn
      (qcover::reset)
      (putd 'qcoverIlsFixtureCall _originalLexicalFixtureCall))))
