;;; Copyright (c) 2025-2026 Bai Junyan and contributors.
;;; SPDX-License-Identifier: LGPL-3.0-or-later
;;; core.ils - Branch coverage for classic SKILL function bodies.

qcover:::_branches = makeTable("qcoverBranches" nil)
qcover:::_hits = makeTable("qcoverHits" 0)
qcover:::_originalDefinitions = makeTable("qcoverOriginalDefinitions" nil)
qcover:::_ilsOriginalDefinitions = makeTable("qcoverIlsOriginalDefinitions" nil)
qcover:::_ownedTemps = nil

(defun qcover:::copyTable (source defaultValue name)
  (let ((resultTable (makeTable name defaultValue)))
    (foreach key source
      (setarray resultTable key source[key]))
    resultTable))
qcover:::_currentFile = nil
qcover:::_currentFunction = nil
qcover:::_nextDecision = 0

(defun qcover::reset ()
  "Restore instrumented functions and clear all coverage state."
  (letseq ((oldDebugMode (status debugMode))
        (completed nil))
    (unwindProtect
      (progn
        (sstatus debugMode t)
        (foreach functionName qcover:::_ilsOriginalDefinitions
          (putd functionName (car qcover:::_ilsOriginalDefinitions[functionName])))
        (foreach functionName qcover:::_originalDefinitions
          (putd functionName qcover:::_originalDefinitions[functionName]))
        (foreach tempFile qcover:::_ownedTemps
          (deleteFile tempFile))
        (setq completed t))
      (sstatus debugMode oldDebugMode))
    (unless completed
      (error "qcover: reset cleanup failed")))

  (setq qcover:::_branches (makeTable "qcoverBranches" nil))
  (setq qcover:::_hits (makeTable "qcoverHits" 0))
  (setq qcover:::_originalDefinitions
        (makeTable "qcoverOriginalDefinitions" nil))
  (setq qcover:::_ilsOriginalDefinitions
        (makeTable "qcoverIlsOriginalDefinitions" nil))
  (setq qcover:::_ownedTemps nil)
  (setq qcover:::_currentFile nil)
  (setq qcover:::_currentFunction nil)
  (setq qcover:::_nextDecision 0)
  t)

(defun qcover:::decision (decisionId value)
  "Record one condition outcome and return its original value."
  (let ((branchId
          (strcat decisionId (if value ":true" ":false"))))
    (setarray qcover:::_hits branchId (add1 qcover:::_hits[branchId]))
    value))

(defun qcover:::registerDecision (condition)
  (letseq ((decisionNumber (add1 qcover:::_nextDecision))
           (decisionId
             (sprintf nil "%s::%s#%d"
                      qcover:::_currentFile
                      (symbolToString qcover:::_currentFunction)
                      decisionNumber))
           (conditionText (sprintf nil "%L" condition)))
    (setq qcover:::_nextDecision decisionNumber)
    (setarray qcover:::_branches (strcat decisionId ":true")
          (list qcover:::_currentFile
                qcover:::_currentFunction
                decisionNumber
                'true
                conditionText))
    (setarray qcover:::_branches (strcat decisionId ":false")
          (list qcover:::_currentFile
                qcover:::_currentFunction
                decisionNumber
                'false
                conditionText))
    decisionId))

(defun qcover:::quotedForm (head)
  (member head '(quote _quote quasiquote _backquote)))

(defun qcover:::transformBindings (bindings)
  (mapcar
    (lambda (binding)
      (if (atom binding)
          binding
          (cons (car binding)
                (mapcar qcover:::transformExpression (cdr binding)))))
    bindings))

(defun qcover:::wrapDecision (condition)
  (let ((decisionId (qcover:::registerDecision condition)))
    (list 'qcover:::decision
          decisionId
          (qcover:::transformExpression condition))))

(defun qcover:::transformIlsTop (expression)
  (if (or (atom expression) (qcover:::quotedForm (car expression)))
      expression
      (let ((head (car expression)))
        (cond
          ((eq head 'defglobalfun)
           (append (list head (cadr expression) (caddr expression))
                   (mapcar qcover:::transformExpression (cdddr expression))))
          ((member head '(lambda nlambda))
           (cons head
                 (cons (cadr expression)
                       (mapcar qcover:::transformExpression
                               (cddr expression)))))
          (t
           (mapcar qcover:::transformIlsTop expression))))))

(defun qcover:::scanIlsDefinitions (expression definitions)
  (unless (atom expression)
    (unless (qcover:::quotedForm (car expression))
      (when (eq (car expression) 'defglobalfun)
        (let ((functionName (cadr expression)))
          (unless definitions[functionName]
            (setarray definitions functionName
                      (list (getd functionName))))))
      (foreach form expression
        (qcover:::scanIlsDefinitions form definitions)))))

(defun qcover:::readIlsForms (fileName)
  (let ((input (infile fileName))
        forms
        line)
    (unless input
      (error "qcover: cannot open %L" fileName))
    (unwindProtect
      (progn
        (while (setq line (lineread input))
          (unless (eq line t)
            (setq forms (append forms line))))
        forms)
      (close input))))

(defun qcover:::writeIlsTemp (directory forms)
  (let ((markers nil)
        (marker nil)
        (candidate nil)
        markerPort
        output
        ownedCandidate
        result
        savedError)
    (setq result
          (errset
            (progn
              (while (null ownedCandidate)
                (setq marker (makeTempFileName (strcat directory "/.qcover-")))
                (setq markerPort (outfile marker "w"))
                (unless markerPort
                  (error "qcover: cannot reserve %L" marker))
                (setq markers (cons marker markers))
                (close markerPort)
                (setq markerPort nil)
                (setq candidate (strcat marker ".ils"))
                (unless (isFile candidate)
                  (setq output (outfile candidate "w"))
                  (unless output
                    (error "qcover: cannot acquire %L" candidate))
                  (setq ownedCandidate candidate)))
              (foreach marker markers
                (deleteFile marker))
              (setq markers nil)
              (foreach form forms
                (pprint form output)
                (newline output))
              (close output)
              (setq output nil)
              ownedCandidate)))
    (unless result
      (setq savedError errset.errset)
      (when markerPort
        (errset (close markerPort)))
      (when output
        (errset (close output)))
      (foreach marker markers
        (errset (deleteFile marker)))
      (when ownedCandidate
        (errset (deleteFile ownedCandidate)))
      (putprop 'errset savedError 'errset)
      (err))
    (car result)))

(defun qcover:::loadIls (normalizedFile attemptDefinitions)
  (letseq ((parts (axlDMFileParts normalizedFile))
           (directory (car parts))
           (forms (qcover:::readIlsForms normalizedFile))
           transformed
           tempFile)
    (foreach form forms
      (qcover:::scanIlsDefinitions form attemptDefinitions))
    (setq qcover:::_currentFile normalizedFile)
    (setq qcover:::_currentFunction 'lexical)
    (setq qcover:::_nextDecision 0)
    (setq transformed
          (mapcar
            (lambda (form)
              (qcover:::transformIlsTop form))
            forms))
    (setq tempFile (qcover:::writeIlsTemp directory transformed))
    (setq qcover:::_ownedTemps (cons tempFile qcover:::_ownedTemps))
    (let ((input (infile tempFile)))
      (unless input
        (error "qcover: cannot open %L" tempFile))
      (unwindProtect
        (loadPort input ?langMode 'ils)
        (close input)))
    (foreach functionName attemptDefinitions
      (unless qcover:::_ilsOriginalDefinitions[functionName]
        (setarray qcover:::_ilsOriginalDefinitions functionName
                  attemptDefinitions[functionName])))
    t))

(defun qcover:::transformCondClause (clause)
  (if (or (atom clause) (null clause))
      clause
      (cons
        (if (eq (car clause) t)
            t
            (qcover:::wrapDecision (car clause)))
        (mapcar qcover:::transformExpression (cdr clause)))))

(defun qcover:::transformExpression (expression)
  (if (atom expression)
      expression
      (let ((head (car expression)))
        (cond
          ((qcover:::quotedForm head)
           expression)
          ((member head '(if when unless))
           (cons head
                 (cons (qcover:::wrapDecision (cadr expression))
                       (mapcar qcover:::transformExpression
                               (cddr expression)))))
          ((eq head 'cond)
           (cons head
                 (mapcar qcover:::transformCondClause
                         (cdr expression))))
          ((member head '(let letseq prog))
           (cons head
                 (cons (qcover:::transformBindings (cadr expression))
                       (mapcar qcover:::transformExpression
                               (cddr expression)))))
          ((member head '(lambda nlambda))
           (cons head
                 (cons (cadr expression)
                       (mapcar qcover:::transformExpression
                               (cddr expression)))))
          (t
           (mapcar qcover:::transformExpression expression))))))

(defun qcover:::transformDefinition (definition)
  (let ((head (car definition)))
    (cond
      ((member head '(procedure nprocedure mprocedure))
       (cons head
             (cons (cadr definition)
                   (mapcar qcover:::transformExpression
                           (cddr definition)))))
      ((member head '(defun defmacro))
       (append (list head (cadr definition) (caddr definition))
               (mapcar qcover:::transformExpression
                       (cdddr definition))))
      (t
       (qcover:::transformExpression definition)))))

(defun qcover:::prettyDefinition (functionName)
  (let ((port (outstring))
        text)
    (unless port
      (error "qcover: cannot create an outstring port"))
    (unwindProtect
      (progn
        ;; pp is an nlambda: construct the call so the actual function symbol
        ;; is passed unevaluated, while the output port is evaluated.
        (eval (list 'pp functionName (list 'quote port)))
        (setq text (getOutstring port)))
      (close port))
    text))

(defun qcover:::instrumentFunction (functionName)
  (letseq ((definitionText (qcover:::prettyDefinition functionName))
           (forms (linereadstring definitionText))
           (definition (car forms))
           transformed)
    (unless definition
      (error "qcover: cannot parse function %L" functionName))

    (setq qcover:::_currentFunction functionName)
    (setq qcover:::_nextDecision 0)
    (unless qcover:::_originalDefinitions[functionName]
      (setarray qcover:::_originalDefinitions functionName
            (getd functionName)))
    (setq transformed (qcover:::transformDefinition definition))
    (loadstring (sprintf nil "%L" transformed) 'il)))

(defun qcover::load (fileName)
  "Load and instrument every classic SKILL function defined by fileName."
  (letseq ((oldDebugMode (status debugMode))
        (normalizedFile (qub::normalizePath (simplifyFilename fileName)))
        (oldBranches qcover:::_branches)
        (oldHits qcover:::_hits)
        (oldOriginalDefinitions qcover:::_originalDefinitions)
        (oldIlsOriginalDefinitions qcover:::_ilsOriginalDefinitions)
        (oldOwnedTemps qcover:::_ownedTemps)
        (oldCurrentFile qcover:::_currentFile)
        (oldCurrentFunction qcover:::_currentFunction)
        (oldNextDecision qcover:::_nextDecision)
        (isIls (equal (cadr (cddr (axlDMFileParts normalizedFile))) "ils"))
        functions
        attemptDefinitions
        savedError
        attemptResult
        success)
    (unwindProtect
      (progn
        (sstatus debugMode t)
        (if isIls
            (progn
              (setq attemptResult
                    (errset
                      (progn
                        (setq qcover:::_branches
                              (qcover:::copyTable oldBranches nil "qcoverBranches"))
                        (setq qcover:::_hits
                              (qcover:::copyTable oldHits 0 "qcoverHits"))
                        (setq qcover:::_originalDefinitions
                              (qcover:::copyTable oldOriginalDefinitions nil
                                                  "qcoverOriginalDefinitions"))
                        (setq qcover:::_ilsOriginalDefinitions
                              (qcover:::copyTable oldIlsOriginalDefinitions nil
                                                  "qcoverIlsOriginalDefinitions"))
                        (setq attemptDefinitions
                              (makeTable "qcoverIlsAttemptDefinitions" nil))
                        (qcover:::loadIls normalizedFile attemptDefinitions))))
              (if attemptResult
                  nil
                  (progn
                    (setq savedError errset.errset)
                    (foreach functionName attemptDefinitions
                      (errset
                        (putd functionName
                              (car attemptDefinitions[functionName]))))
                    (foreach tempFile (setof temp qcover:::_ownedTemps
                                            (not (member temp oldOwnedTemps)))
                      (errset (deleteFile tempFile)))
                    (setq qcover:::_branches oldBranches)
                    (setq qcover:::_hits oldHits)
                    (setq qcover:::_originalDefinitions oldOriginalDefinitions)
                    (setq qcover:::_ilsOriginalDefinitions oldIlsOriginalDefinitions)
                    (setq qcover:::_ownedTemps oldOwnedTemps)
                    (setq qcover:::_currentFile oldCurrentFile)
                    (setq qcover:::_currentFunction oldCurrentFunction)
                    (setq qcover:::_nextDecision oldNextDecision)
                    (putprop 'errset savedError 'errset)
                    (err))))
            (progn
              (load normalizedFile)
              (setq functions
                    (getFunctions (qub::getFileName normalizedFile)))
              (setq qcover:::_currentFile normalizedFile)
              (foreach functionName functions
                (qcover:::instrumentFunction functionName))))
        (setq success t))
      (progn
        (sstatus debugMode oldDebugMode)
        (unless (or success isIls)
          (qcover::reset))
        (when (and savedError (not success))
          (putprop 'errset savedError 'errset))))
    t))

(defun qcover:::coverageCounts ()
  "Return (covered total) for the registered branch outcomes."
  (let ((covered 0)
        (total 0))
    (foreach branchId qcover:::_branches
      (setq total (add1 total))
      (when (greaterp qcover:::_hits[branchId] 0)
        (setq covered (add1 covered))))
    (list covered total)))

(defun qcover::report (@key (minimum nil) (port nil))
  "Print branch coverage, optionally failing below minimum percent."
  (when (and minimum
             (or (not (numberp minimum))
                 (lessp minimum 0)
                 (greaterp minimum 100)))
    (error "qcover: minimum must be between 0 and 100"))

  (letseq ((counts (qcover:::coverageCounts))
           (covered (car counts))
           (total (cadr counts))
           (percentage
             (if (zerop total)
                 100.0
                 (quotient (times 100.0 covered) total)))
           (outPort (if port port poport)))
    (fprintf outPort "qcover: %d/%d branches covered (%.2f%%)\n"
            covered total percentage)
    (foreach branchId qcover:::_branches
      (when (zerop qcover:::_hits[branchId])
        (let ((metadata qcover:::_branches[branchId]))
          (fprintf outPort "  missing %s::%L#%d %L: %s\n"
                  (car metadata)
                  (cadr metadata)
                  (nth 2 metadata)
                  (nth 3 metadata)
                  (nth 4 metadata)))))

    (when (and minimum (lessp percentage minimum))
      (error "qcover: branch coverage %.2f%% is below %.2f%%"
             percentage minimum))
    percentage))
