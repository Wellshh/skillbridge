;;; Copyright (c) 2019-2024 the skillbridge authors (Niels Buwen, Tobias Markus)
;;; Derived from skillbridge (https://github.com/unihd-cag/skillbridge)
;;; SPDX-License-Identifier: LGPL-3.0-only
let((_filename _moduleFolder _logDirectory
     __pyStartServer __pyKillServer __pyRestartServer __pyReloadScript
     __pyShowLog __pySpawnServer __pyOnData __pyOnError __pyOnFinish
     __pyOnDataScript __pyOnFinishScript __pyCaptureWarnings
     __pyEvalLine
     __pyPropertyListToPython __pyStableRemoteVariable
     __pySaveToVariableAndReturn __pyListToPython __pyVectorToPython
     __pyTableToPython __pySkillToPython __pyRunScript
     remoteRegistry serverEntry)

    (setq _filename (get_filename piport))
    (setq _filename (pcreReplace(pcreCompile("^ +| +$") _filename "" 0)))
    (setq _moduleFolder (pcreReplace(
        pcreCompile("[\\\\/][^\\\\/]+[\\\\/][^\\\\/]+[\\\\/][^\\\\/]+[\\\\/][^\\\\/]+$")
        _filename "" 0
    )))
    (setq _logDirectory (or (getShellEnvVar "ALLEGROBRIDGE_LOG_DIRECTORY") "."))
    ; Thin wrappers around the internal (non-redefinable) IPC built-ins so that
    ; tests can putd-mock them. User-defined, so they carry no "internal" flag.
    (defglobalfun __pyIpcBeginProcess (@rest args)
        apply('ipcBeginProcess args)
    )

    (defglobalfun __pyIpcKillProcess (@rest args)
        apply('ipcKillProcess args)
    )

    (defglobalfun __pyIpcWriteProcess (@rest args)
        apply('ipcWriteProcess args)
    )

    (defglobalfun __pyWriteFrame (id marker payload)
        (setq payload (pcreReplace(
            __pyWriteFrame.ESCPattern
            payload
            strcat(__pyWriteFrame.ESC __pyWriteFrame.ESC)
            0
        )))
        (setq payload (pcreReplace(
            __pyWriteFrame.RSPattern
            payload
            strcat(__pyWriteFrame.ESC __pyWriteFrame.RS)
            0
        )))
        __pyIpcWriteProcess(
            id
            lsprintf("%s%s%s" marker payload __pyWriteFrame.RS)
        )
    )

    ; Frame markers match protocol/response.py: STX, NAK, RST start payload; RS ends it.
    __pyWriteFrame.STX = strcat(intToChar(2))
    __pyWriteFrame.NAK = strcat(intToChar(21))
    __pyWriteFrame.RST = strcat(intToChar(18))
    __pyWriteFrame.ESC = strcat(intToChar(27))
    __pyWriteFrame.RS = strcat(intToChar(30))
    __pyWriteFrame.ESCPattern = pcreCompile(__pyWriteFrame.ESC)
    __pyWriteFrame.RSPattern = pcreCompile(__pyWriteFrame.RS)

    (defglobalfun __pyIpcWait (@rest args)
        apply('ipcWait args)
    )

    (setq __pySpawnServer (lambda ()
        let((executableWithArgs process oldPythonPath)
            pyStartServer.state = 'starting
            pyStartServer.receiveBuffer = ""

            (setq executableWithArgs (lsprintf(
                "%s %s"
                pyStartServer.id
                pyStartServer.logLevel
            ))

            if(pyStartServer.singleMode then
                (setq executableWithArgs (lsprintf(
                    "%s --single"
                    executableWithArgs
                )))
            )

            if(pyStartServer.forceTcp then
                (setq executableWithArgs (lsprintf(
                    "%s --force-tcp"
                    executableWithArgs
                )))
            )

            if(pyStartServer.timeout then
                (setq executableWithArgs (lsprintf(
                    "%s --timeout %L"
                    executableWithArgs
                    pyStartServer.timeout
                )))
            )

            (setq executableWithArgs (lsprintf(
                "\"%s\" -m allegrobridge._kernel.server.python_server %s"
                pyStartServer.python
                executableWithArgs
            )))

            (setq oldPythonPath (getShellEnvVar "PYTHONPATH"))
            (setq process (unwindProtect(
                progn(
                    setShellEnvVar("PYTHONPATH" pyStartServer.moduleFolder)
                    __pyIpcBeginProcess(
                        executableWithArgs
                        ""
                        __pyOnData
                        __pyOnError
                        __pyOnFinish
                        pyStartServer.logName
                    )
                )
                if(oldPythonPath then
                    setShellEnvVar("PYTHONPATH" oldPythonPath)
                else
                    unsetShellEnvVar("PYTHONPATH")
                )
            )))

            if(process then
                pyStartServer.ipc = process
                pyStartServer.state = 'running
                t
            else
                pyStartServer.ipc = nil
                pyStartServer.state = 'stopped
                fprintf(stderr "failed to start server\n")
                nil
            )
        )
    ))

    (setq __pyKillServer (lambda ()
        if(!pyStartServer.ipc then
            printf("server was not running\n")
            nil
        else
            pyStartServer.restartPending = nil
            pyStartServer.state = 'stopping

            ; ipcKillProcess only requests termination. The process handle
            ; remains owned by __pyOnFinish until the matching callback arrives.
            __pyIpcKillProcess(pyStartServer.ipc)
            t
        )
    ))

    (setq __pyRestartServer (lambda ()
        if(!pyStartServer.ipc then
            funcall(__pySpawnServer)
        else
            pyStartServer.restartPending = t
            pyStartServer.state = 'restarting

            if(pyStartServer.requestIpc == pyStartServer.ipc then
                t
            else
                __pyIpcKillProcess(pyStartServer.ipc)
                t
            )
        )
    ))

    (setq __pyReloadScript (lambda ()
        printf("killing the old server\n")
        pyKillServer()
        load(pyReloadServer.filename)
        t
    ))

    pyReloadServer.filename = _filename

    (setq __pyShowLog (lambda (@optional (length 20) "x")
        if(!fixp(length) || length <= 0 then
            fprintf(
                stderr
                "pyShowLog: length must be a positive integer\n"
            )
            nil
        else
            let((
                fin
                line
                (lines declare(lines[length]))
                (ptr 0)
                (count 0)
                (start 0)
                i
            )
                (setq fin (infile pyShowLog.logName))

                if(!fin then
                    fprintf(
                        stderr
                        "pyShowLog: cannot open log file %s\n"
                        pyShowLog.logName
                    )
                    nil
                else
                    unwindProtect(
                        while(gets(line fin)
                            lines[ptr] = line
                            (setq ptr (mod (+ ptr 1) length))

                            when(count < length
                                (setq count (+ count 1))
                            )
                        )
                        close(fin)
                    )

                    ; Before the buffer fills, valid lines start at index 0.
                    ; After it fills, ptr points to the oldest retained line.
                    if(count < length then
                        (setq start 0)
                    else
                        (setq start ptr)
                    )

                    when(count > 0
                        for(i 0 count-1
                            printf(
                                "%s"
                                lines[mod(start + i length)]
                            )
                        )
                    )

                    printf("")
                    t
                )
            )
        )
    ))

    pyShowLog.logName = lsprintf(
        "%s/allegrobridge_skill.log"
        _logDirectory
    )

    (setq __pyEvalLine
        (lambda (line)
            (let (tempPort oldPort captured completed result resultValue resultBound outerError)
                (setq tempPort (outstring))
                (setq oldPort (symeval 'woport))
                (unwindProtect
                    (progn
                        (set 'woport tempPort)
                        (setq completed (errset (setq result (evalstring line 'il))))
                        (setq resultBound (boundp 'result (theEnvironment)))
                        (when resultBound (setq resultValue result))
                        (unless completed (setq outerError errset.errset))
                        (warn "")
                        (getWarn)
                        (setq captured (getOutstring tempPort))
                        (list completed
                              resultBound resultValue outerError captured))
                    (progn
                        (set 'woport oldPort)
                        (close tempPort))))))

    (setq __pyOnData (lambda (id data)
        when(and(id == pyStartServer.ipc
                 eq(serverEntry (getd 'pyStartServer)))
            let((newlineTail lineLength line)
                pyStartServer.receiveBuffer = strcat(
                    pyStartServer.receiveBuffer
                    data
                )
                (setq newlineTail (index pyStartServer.receiveBuffer "\n"))

                while(newlineTail
                    (setq lineLength (- (strlen pyStartServer.receiveBuffer) (strlen newlineTail)))
                    when(
                        lineLength > 0 &&
                        substring(pyStartServer.receiveBuffer lineLength 1) == strcat(intToChar(13))
                        (setq lineLength (- lineLength 1))
                    )
                    when(lineLength > 0
                        (setq line (substring(
                            pyStartServer.receiveBuffer
                            1
                            lineLength
                        )))
                    )
                    pyStartServer.receiveBuffer =
                        substring(newlineTail 2) || ""

                    when(lineLength > 0
                        let((evaluation result capturedWarning pythonCode responseMarker completed boundResult outerError)
                            ; Remember which process is currently executing the request.
                            pyStartServer.requestIpc = id

                            (setq evaluation (funcall __pyEvalLine line))
                            (setq completed (car evaluation))
                            (setq boundResult (cadr evaluation))
                            (setq result (caddr evaluation))
                            (setq outerError (cadddr evaluation))
                            (setq capturedWarning (nth 4 evaluation))

                            if(boundResult then
                                if(completed then
                                    (setq pythonCode (funcall __pySkillToPython result))

                                    if(
                                        capturedWarning != "" &&
                                        capturedWarning != "*WARNING* "
                                    then
                                        (setq pythonCode (lsprintf(
                                            "warning(%L, %s)"
                                            capturedWarning
                                            pythonCode
                                        )))
                                    )

                                    if(
                                        pyStartServer.restartPending &&
                                        id == pyStartServer.ipc
                                    then
                                        (setq responseMarker __pyWriteFrame.RST)
                                    else
                                        (setq responseMarker __pyWriteFrame.STX)
                                    )

                                    __pyWriteFrame(
                                        id
                                        responseMarker
                                        pythonCode
                                    )
                                else
                                    printf(
                                        "command %L resulted in error %L\n"
                                        line
                                        outerError
                                    )
                                    __pyWriteFrame(
                                        id
                                        __pyWriteFrame.NAK
                                        lsprintf("%L" outerError)
                                    )
                                )
                            else
                                __pyWriteFrame(
                                    id
                                    __pyWriteFrame.STX
                                    "error('unbound')"
                                )
                            )

                            pyStartServer.requestIpc = nil
                        )
                    )

                    (setq newlineTail (index pyStartServer.receiveBuffer "\n"))
                )
            )
        )
    )

    (setq __pyOnDataScript (lambda (id data)
        foreach(line parseString(data "\n")
            let((evaluation result capturedWarning pythonCode completed boundResult outerError)
                (setq evaluation (funcall __pyEvalLine line))
                (setq completed (car evaluation))
                (setq boundResult (cadr evaluation))
                (setq result (caddr evaluation))
                (setq outerError (cadddr evaluation))
                (setq capturedWarning (nth 4 evaluation))
                if(boundResult then
                    if(completed then
                        (setq pythonCode (funcall __pySkillToPython result))
                        if(capturedWarning != "" && capturedWarning != "*WARNING* " then
                            (setq pythonCode (lsprintf "warning(%L, %s)" capturedWarning pythonCode)))
                        __pyIpcWriteProcess(id lsprintf("success %s\n" pythonCode))
                    else
                        printf("command %L resulted in error %L\n" line outerError)
                        __pyIpcWriteProcess(id lsprintf("failure %L\n" outerError))
                    )
                else
                    __pyIpcWriteProcess(id "success error('unbound')\n")
                )
            )
        )
    ))

    (setq __pyOnError (lambda (_ data)
        fprintf(stderr "PYTHON: %s\n" data)
    ))

    (setq __pyOnFinish (lambda (id exitStatus)
        if(and(id == pyStartServer.ipc
               eq(serverEntry (getd 'pyStartServer))) then
            let((shouldRestart)
                printf(
                    "server was stopped with code %L\n"
                    exitStatus
                )

                (setq shouldRestart pyStartServer.restartPending)

                pyStartServer.ipc = nil
                pyStartServer.requestIpc = nil
                pyStartServer.restartPending = nil
                pyStartServer.receiveBuffer = ""
                pyStartServer.state = 'stopped

                when(shouldRestart
            (funcall __pySpawnServer)
                )
            )
        else
            printf(
                "ignoring stale server finish callback with code %L\n"
                exitStatus
            )
        )
    ))

    (setq __pyOnFinishScript (lambda (_ data)
        printf("script finished with code %L\n" data)
    ))

    (setq __pyPropertyListToPython (lambda (propList)
        ; Iterate (key val ...) directly to preserve DPL order (propList->? order is unspecified).
        let((rest parts)
            (setq rest (cdr propList))
            while(rest
                (setq parts (cons(
                    lsprintf("'%s':%s" car(rest) (funcall __pySkillToPython (cadr rest)))
                    parts
                )))
                (setq rest (cddr rest))
            )
            strcat(
                "{"
                buildString(reverse(parts) ",")
                "}"
            )
        )
    ))

    (setq __pyStableRemoteVariable (lambda (thing prefix)
        let((rest entry variableSymbol)
            (setq rest remoteRegistry)
            while(and(rest !variableSymbol)
                (setq entry (car rest))
                when(equal(cadr(entry) thing)
                    (setq variableSymbol (car entry))
                )
                (setq rest (cdr rest))
            )
            if(!variableSymbol then
                (setq variableSymbol (gensym prefix))
                set(variableSymbol thing)
                (setq remoteRegistry (cons(
                    list(variableSymbol thing)
                    remoteRegistry
                )))
            )
            lsprintf("Remote(%L)" symbolToString(variableSymbol))
        )
    ))

    (setq __pySaveToVariableAndReturn (lambda (thing)
        let((repr variableName split objectType address)
            (setq repr (lsprintf "%L" thing))

            if(rexExecute(repr) then
                (setq split (buildString (parseString repr "_") ""))
                (setq split (parseString split "@:"))
                (setq objectType (car split))
                (setq address (cadr split))
                (setq variableName (lsprintf(
                    "__py_%s_%s"
                    objectType
                    address
                )))
                set(stringToSymbol(variableName) thing)
                lsprintf("Remote(%L)" variableName)
            else if(otherp(thing) then
                (funcall __pyStableRemoteVariable thing "__py_OTHER_")
            else if(portp(thing) then
                (funcall __pyStableRemoteVariable thing "__py_openfile_")
            else
                printf("I COULD NOT PARSE %L\n" repr)
                lsprintf("error(%L)" repr)
            )))
        )
    ))

    (setq __pyListToPython (lambda (thing)
        strcat(
            "["
            buildString(mapcar(__pySkillToPython thing) ",")
            "]"
        )
    ))

    (setq __pyVectorToPython (lambda (collection)
        let((symbol)
            (setq symbol (gensym "__py_vector_"))
            set(symbol collection)
            lsprintf(
                "Vector(%L)"
                symbolToString(symbol)
            )
        )
    ))

    (setq __pyTableToPython (lambda (collection)
        let((symbol)
            (setq symbol (gensym "__py_table_"))
            set(symbol collection)
            lsprintf(
                "Table(%L)"
                symbolToString(symbol)
            )
        )
    ))

    (setq __pySkillToPython (lambda (thing)
        if(thing == t then
            "True"
        else if(!thing then
            "None"
        else if(or(numberp(thing) stringp(thing)) then
            lsprintf("%L" thing)
        else if(symbolp(thing) then
            lsprintf("Symbol('%s')" thing)
        else if(listp(thing) then
            if(
                and(
                    !car(thing)
                    symbolp(cadr(thing))
                    cadr(thing) != t
                )
            then
                (funcall __pyPropertyListToPython thing)
            else
                (funcall __pyListToPython thing)
            )
        else if(tablep(thing) then
            (funcall __pyTableToPython thing)
        else if(vectorp(thing) then
            (funcall __pyVectorToPython thing)
        else
            rexCompile("^[_a-zA-Z]+[:@][x0-9a-fA-F]+$")
            (funcall __pySaveToVariableAndReturn thing)
        )))))))
    ))

    (setq __pyStartServer (lambda (
        @key
        (id "default")
        (logLevel "INFO")
        (singleMode nil)
        (timeout nil)
        (python "python")
        (forceTcp nil)
        "ttggtg"
    )
        if(pyStartServer.ipc then
            fprintf(stderr "server is already running\n")
            nil
        else
            pyStartServer.id = id
            pyStartServer.logLevel = logLevel
            pyStartServer.singleMode = singleMode
            pyStartServer.timeout = timeout
            pyStartServer.python = python
            pyStartServer.forceTcp = forceTcp
            pyStartServer.restartPending = nil

            (funcall __pySpawnServer)
        )
    ))

    pyStartServer.logName = lsprintf(
        "%s/allegrobridge_skill.log"
        _logDirectory
    )

    (setq __pyRunScript (lambda (
        script
        @key
        (python "")
        (args nil)
        (block nil)
        "ttlg"
    )
        let((effectivePython command process oldPythonPath active buffer dataHandler postHandler)
            (setq active t)
            (setq buffer "")
            (setq effectivePython (if(python == "" then pyStartServer.python else python)))
            (setq command (lsprintf(
                "%s %s %s"
                effectivePython
                script
                buildString(args)
            )))
            (setq dataHandler
                (lambda (id data)
                    (when(and active (eq id process))
                        (setq buffer (strcat buffer data))
                        (let (newlineTail lineLength line evaluation result capturedWarning completed boundResult outerError pythonCode)
                            (setq newlineTail (index buffer "\n"))
                            (while newlineTail
                                (setq lineLength (- (strlen buffer) (strlen newlineTail)))
                                (when(and (> lineLength 0)
                                          (equal (substring buffer lineLength 1) (strcat (intToChar 13))))
                                    (setq lineLength (- lineLength 1)))
                                (when(> lineLength 0)
                                    (setq line (substring buffer 1 lineLength))
                                    (setq evaluation (funcall __pyEvalLine line))
                                    (setq completed (car evaluation))
                                    (setq boundResult (cadr evaluation))
                                    (setq result (caddr evaluation))
                                    (setq outerError (cadddr evaluation))
                                    (setq capturedWarning (nth 4 evaluation))
                                    (if boundResult then
                                        (if completed then
                                            (setq pythonCode (funcall __pySkillToPython result))
                                            (when(and (not (equal capturedWarning ""))
                                                      (not (equal capturedWarning "*WARNING* ")))
                                                (setq pythonCode (lsprintf "warning(%L, %s)" capturedWarning pythonCode)))
                                            (__pyIpcWriteProcess id (lsprintf "success %s\n" pythonCode))
                                        else
                                            (__pyIpcWriteProcess id (lsprintf "failure %L\n" outerError)))
                                    else
                                        (__pyIpcWriteProcess id "success error('unbound')\n")))
                                (setq buffer (or (substring newlineTail 2) ""))
                                (setq newlineTail (index buffer "\n")))))))
            (setq postHandler
                (lambda (id exitStatus)
                    (when(eq id process)
                        (setq active nil)
                        (printf "script finished with code %L\n" exitStatus))))

            (setq oldPythonPath (getShellEnvVar "PYTHONPATH"))
            (setq process (unwindProtect(
                progn(
                    setShellEnvVar("PYTHONPATH" pyStartServer.moduleFolder)
                    __pyIpcBeginProcess(
                        command
                        ""
                        dataHandler
                        __pyOnError
                        postHandler
                        pyRunScript.logName
                    )
                )
                if(oldPythonPath then
                    setShellEnvVar("PYTHONPATH" oldPythonPath)
                else
                    unsetShellEnvVar("PYTHONPATH")
                )
            )))

            if(block then
                (__pyIpcWait process)
            else
                process
            )
        )
    ))

    pyRunScript.logName = lsprintf(
        "%s/allegrobridge_script.log"
        _logDirectory
    )

    pyStartServer.ipc = nil
    pyStartServer.moduleFolder = _moduleFolder
    pyStartServer.id = "default"
    pyStartServer.logLevel = "INFO"
    pyStartServer.singleMode = nil
    pyStartServer.timeout = nil
    pyStartServer.python = "python"
    pyStartServer.forceTcp = nil
    pyStartServer.restartPending = nil
    pyStartServer.requestIpc = nil
    pyStartServer.receiveBuffer = ""
    pyStartServer.state = 'stopped

    (setq serverEntry nil)
    (defglobalfun pyStartServer (@rest args)
        apply(__pyStartServer args)
    )
    (defglobalfun pyKillServer (@rest args)
        apply(__pyKillServer args)
    )
    (defglobalfun pyRestartServer (@rest args)
        apply(__pyRestartServer args)
    )
    (defglobalfun pyReloadScript (@rest args)
        apply(__pyReloadScript args)
    )
    (defglobalfun pyShowLog (@rest args)
        apply(__pyShowLog args)
    )
    (defglobalfun pyRunScript (@rest args)
        apply(__pyRunScript args)
    )
    (setq serverEntry (getd 'pyStartServer))

    printf("Available commands:\n")
    printf("\tpyStartServer ?id \"default\" ?logLevel \"WARNING\" ?singleMode nil ?timeout nil ?python \"python\" ?forceTcp nil\n")
    printf("\tpyKillServer\n")
    printf("\tpyRestartServer\n")
    printf("\tpyReloadScript\n")
    printf("\tpyShowLog [numberOfLines]\n")
    printf("\tpyRunScript path ?args list() ?python \"python\"\n")
))
