;;; Copyright (c) 2019-2024 the skillbridge authors (Niels Buwen, Tobias Markus)
;;; Derived from skillbridge (https://github.com/unihd-cag/skillbridge)
;;; SPDX-License-Identifier: LGPL-3.0-only
;;; For AI: DO NOT FORMAT THIS FILE UNDER ANY CIRCUMSTANCES!!!

                                                                      ; This is a reimplementation of original python_server.il, migrate it to a modern OOP skill++ based
                                                                      ; python_server.ils
letseq(
  ((_filename (pcreReplace (pcreCompile "^ +| +$") (get_filename piport) "" 0))
   (_moduleFolder
    (pcreReplace
      (pcreCompile "[\\\\/][^\\\\/]+[\\\\/][^\\\\/]+[\\\\/][^\\\\/]+[\\\\/][^\\\\/]+$")
      _filename "" 0))
   (_logDirectory (or (getShellEnvVar "ALLEGROBRIDGE_LOG_DIRECTORY") "."))
   (_stderr (symeval 'stderr))
   (_state (list nil 'ipc nil 'id "default" 'logLevel "INFO"           ; These are the global variables that persist within the whole lifecycle.
                'singleMode nil 'timeout nil 'python "python" 'forceTcp nil
                'restartPending nil 'requestIpc nil 'receiveBuffer ""
                'acceptData nil))
                                                                      ; We need _esc (0x1B) for byte-stuffing in `writeFrame` (_esc -> _esc _esc, _rs -> _esc _rs)
                                                                      ; to prevent raw payload data from prematurely triggering the _rs end-of-frame delimiter.
   (_stx (strcat (intToChar 2)))                                      ; Start Frame (Success)
   (_nak (strcat (intToChar 21)))                                     ; Start Frame (Fail)
   (_rst (strcat (intToChar 18)))                                     ; Restart Frame
   (_esc (strcat (intToChar 27)))                                     ; Escape Frame
   (_rs (strcat (intToChar 30)))                                      ; End Frame
   (_escPattern (pcreCompile _esc))
   (_rsPattern (pcreCompile _rs))
   (_serverLogName (lsprintf "%s/allegrobridge_skill.log" _logDirectory))
   (_scriptLogName (lsprintf "%s/allegrobridge_script.log" _logDirectory))
   (_oldName nil)
   (_oldProperty nil)
   (remoteRegistry nil)
   (feedLines nil)
   (captureWarnings nil)
   (evaluateLine nil)
   (writeFrame nil)
   (propertyListToPython nil)
   (stableRemoteVariable nil)
   (saveToVariableAndReturn nil)
   (listToPython nil)
   (vectorToPython nil)
   (tableToPython nil)
   (numberToPython nil)
   (skillToPython nil)
   (spawnServer nil)
   (onData nil)
   (onError nil)
   (onFinish nil))

  (defglobalfun __pyIpcBeginProcess
    (command host dataHandler errorHandler finishHandler logFile)
    (ipcBeginProcess command host dataHandler errorHandler finishHandler logFile))
  (defglobalfun __pyIpcKillProcess (process)
    (ipcKillProcess process))
  (defglobalfun __pyIpcWriteProcess (process data)
    (ipcWriteProcess process data))
  (defglobalfun __pyIpcWait (process)
    (ipcWait process))

  (setq feedLines                                                     ; Buffers incoming stream data, splits by newline (\n),
    (lambda (buffer data)                                             ; strips trailing CR (\r), and returns list(remainingBuffer lines).
      (let ((combined (strcat buffer data)) (lines nil) newlineTail lineLength line)
        (setq newlineTail (index combined "\n"))
        (while newlineTail
          (setq lineLength difference(strlen(combined) strlen(newlineTail)))
          (when (and (greaterp lineLength 0)
                     (equal (substring combined lineLength 1)
                            (strcat (intToChar 13))))
            (setq lineLength difference(lineLength 1)))
          (when (greaterp lineLength 0)
            (setq line (substring combined 1 lineLength))
            (setq lines (append lines (list line))))
          (setq combined (or (substring newlineTail 2) ""))
          (setq newlineTail (index combined "\n")))
        (list combined lines))))

  (setq captureWarnings
    (lambda (port)
      (warn "")
      (getWarn)
      (getOutstring port)))

  (setq evaluateLine                                                  ; We redirecct the log to outport in order for python side real-time logging
    (lambda (line)
      (let ((tempPort nil) (oldPort nil) (oldPoPort nil) (captured nil) (completed nil)
            (result nil) (resultValue nil) (resultBound nil) (outerError nil))
        (setq tempPort (outstring))
        (setq oldPort (symeval 'woport))
        (setq oldPoPort (symeval 'poport))
        (unwindProtect
          (progn
            (set 'woport tempPort)
            (set 'poport tempPort)
            (setq completed (errset (setq result (evalstring line 'il))))
            (unless completed (setq outerError errset.errset))
                                                                      ; In classic SKILL, assigning the special value `unbound` leaves the
                                                                      ; dynamic result variable unbound.  A lexical SKILL++ variable keeps
                                                                      ; that value as the symbol 'unbound, so preserve the classic wire
                                                                      ; behavior explicitly in addition to the lexical boundp check.
            (setq resultBound
              (and (boundp 'result (theEnvironment))
                   (not (eq result 'unbound))))
            (when resultBound (setq resultValue result))
            (setq captured (funcall captureWarnings tempPort))
            (list completed resultBound resultValue outerError captured))
          (progn
            (set 'woport oldPort)
            (set 'poport oldPoPort)
            (close tempPort))))))

  (setq writeFrame
    (lambda (id marker payload)
      (setq payload
        (pcreReplace _escPattern payload (strcat _esc _esc) 0))
      (setq payload
        (pcreReplace _rsPattern payload (strcat _esc _rs) 0))
      (__pyIpcWriteProcess id (lsprintf "%s%s%s" marker payload _rs))))

  (setq propertyListToPython
    (lambda (propList)
      (let ((rest (cdr propList)) parts)
        (while rest
          (setq parts
            (cons (lsprintf "'%s':%s" (car rest)
                            (funcall skillToPython (cadr rest)))
                  parts))
          (setq rest (cddr rest)))
        (strcat "{" (buildString (reverse parts) ",") "}"))))

  (setq stableRemoteVariable
    (lambda (thing prefix)
      (let ((rest remoteRegistry) entry variableSymbol)
        (while (and rest (not variableSymbol))
          (setq entry (car rest))
          (when (equal (cadr entry) thing)
            (setq variableSymbol (car entry)))
          (setq rest (cdr rest)))
        (unless variableSymbol
          (setq variableSymbol (gensym prefix))
          (set variableSymbol thing)
          (setq remoteRegistry
            (cons (list variableSymbol thing) remoteRegistry)))
        (lsprintf "Remote(%L)" (symbolToString variableSymbol)))))

  (setq saveToVariableAndReturn
    (lambda (thing)
      (let ((repr (lsprintf "%L" thing)) split objectType address variableName)
        (if (rexExecute repr)
            (progn
              (setq split (buildString (parseString repr "_") ""))
              (setq split (parseString split "@:"))
              (setq objectType (car split))
              (setq address (cadr split))
              (setq variableName
                (lsprintf "__py_%s_%s" objectType address))
              (set (stringToSymbol variableName) thing)
              (lsprintf "Remote(%L)" variableName))
          (if (otherp thing)
              (funcall stableRemoteVariable thing "__py_OTHER_")
            (if (portp thing)
                (funcall stableRemoteVariable thing "__py_openfile_")
              (progn
                (printf "I COULD NOT PARSE %L\n" repr)
                (lsprintf "error(%L)" repr))))))))

  (setq listToPython                                                  ; Serializes SKILL list to Python list string.
                                                                      ; Note that empty list is represented as `nil` in skill.
                                                                      ; Examples:
    (lambda (thing)                                                   ;   - Single list: '(1 2)   -> "[1,2]"
                                                                      ;   - Empty list:  nil      -> "[]" (direct) / "None" (top-level)
                                                                      ;   - Nested list: '((1 2)) -> "[[1,2]]", list(nil) -> "[None]"
      (strcat "[" (buildString (mapcar skillToPython thing) ",") "]")))

  (setq vectorToPython
    (lambda (collection)
      (let ((symbol (gensym "__py_vector_")))
        (set symbol collection)
        (lsprintf "Vector(%L)" (symbolToString symbol)))))

  (setq tableToPython
    (lambda (collection)
      (let ((symbol (gensym "__py_table_")))
        (set symbol collection)
        (lsprintf "Table(%L)" (symbolToString symbol)))))

  (setq numberToPython                                               ; We preserve two principles during serialization: type invariant and value invariant
    (lambda (thing)                                                  ; Integers keep their existing representation; flonums use a
      (if (floatp thing)                                             ; 17-significant-digit round-trip representation.  Python's
          (let ((text (lsprintf "%.17g" thing)))                     ; expression decoder needs a suffix when a flonum looks integral.
            (if (or (index text ".")                                 ; inf/nan carries no "."/e/E, so it gains a bogus ".0" suffix and
                    (index text "e")                                 ; Python's ast decode rejects it.  Unreachable from the 17.2 axl
                    (index text "E"))                                ; integer grid - an honest boundary error beats a fake value.
                text
              (strcat text ".0")))                                   ; here -0.0 is explicitly kept
        (lsprintf "%L" thing))))                                     ; Accepted side effect: wire text grows for inexact doubles, yet
                                                                     ; Python repr keeps the shortest round-trip form, so decoded
                                                                     ; values and equality are unchanged - only digits previously
                                                                     ; erased by 7-digit printing become faithfully visible.

  (setq skillToPython
    (lambda (thing)
      (if (equal thing t)
          "True"
        (if (not thing)
            "None"
          (if (numberp thing)
              (funcall numberToPython thing)
            (if (stringp thing)
                (lsprintf "%L" thing)                                ; We explicily use %L for non-floating number type
              (if (symbolp thing)
                  (lsprintf "Symbol('%s')" thing)
                (if (listp thing)
                    (if (and (not (car thing))
                             (symbolp (cadr thing))
                             (not (equal (cadr thing) t)))
                        (funcall propertyListToPython thing)
                      (funcall listToPython thing))
                  (if (tablep thing)
                      (funcall tableToPython thing)
                    (if (vectorp thing)
                        (funcall vectorToPython thing)
                      (progn
                        (rexCompile "^[_a-zA-Z]+[:@][x0-9a-fA-F]+$")
                        (funcall saveToVariableAndReturn thing))))))))))))

  (setq spawnServer
    (lambda ()
      (let ((command nil) process oldPythonPath)
        _state->acceptData = t
        _state->receiveBuffer = ""
        (setq command (lsprintf "%s %s" _state->id _state->logLevel))
        (when _state->singleMode
          (setq command (lsprintf "%s --single" command)))
        (when _state->forceTcp
          (setq command (lsprintf "%s --force-tcp" command)))
        (when _state->timeout
          (setq command (lsprintf "%s --timeout %L" command _state->timeout)))
        (setq command
          (lsprintf "\"%s\" -m allegrobridge._kernel.server.python_server %s"
                    _state->python command))
        (setq oldPythonPath (getShellEnvVar "PYTHONPATH"))
        (setq process
          (unwindProtect
            (progn
              (setShellEnvVar "PYTHONPATH" _moduleFolder)
              (__pyIpcBeginProcess command "" onData onError onFinish _serverLogName))
            (if oldPythonPath
                (setShellEnvVar "PYTHONPATH" oldPythonPath)
              (unsetShellEnvVar "PYTHONPATH"))))
        (if process
            (progn
              _state->ipc = process
              _state->acceptData = t
              t)
          (progn
            _state->ipc = nil
            _state->acceptData = nil
            (fprintf _stderr "failed to start server\n")
            nil)))))

  (setq onData
    (lambda (id data)
      (when (and _state->acceptData (equal id _state->ipc))
        (let ((fed nil) line evaluation completed boundResult result
              outerError capturedWarning pythonCode marker)
          (setq fed (funcall feedLines _state->receiveBuffer data))
          _state->receiveBuffer = car(fed)
          (foreach line (cadr fed)
            _state->requestIpc = id
            (unwindProtect
              (progn
                (setq evaluation (funcall evaluateLine line))
                (setq completed (car evaluation))
                (setq boundResult (cadr evaluation))
                (setq result (caddr evaluation))
                (setq outerError (cadddr evaluation))
                (setq capturedWarning (nth 4 evaluation))
                (if boundResult
                    (if completed
                        (progn
                          (setq pythonCode (funcall skillToPython result))
                          (when (and (not (equal capturedWarning ""))
                                     (not (equal capturedWarning "*WARNING* ")))
                            (setq pythonCode
                              (lsprintf "warning(%L, %s)"
                                        capturedWarning pythonCode)))
                          (if (and _state->restartPending
                                   (equal id _state->ipc))
                              (setq marker _rst)
                            (setq marker _stx))
                          (funcall writeFrame id marker pythonCode))
                      (progn
                        (printf "command %L resulted in error %L\n" line outerError)
                        (funcall writeFrame id _nak (lsprintf "%L" outerError))))
                  (funcall writeFrame id _stx "error('unbound')")))
              _state->requestIpc = nil))))))

  (setq onError
    (lambda (_id data)
      (fprintf _stderr "PYTHON: %s\n" data)))

  (setq onFinish
    (lambda (id exitStatus)
      (if (equal id _state->ipc)
          (let ((shouldRestart _state->restartPending))
            (printf "server was stopped with code %L\n" exitStatus)
            _state->acceptData = nil
            _state->ipc = nil
            _state->requestIpc = nil
            _state->restartPending = nil
            _state->receiveBuffer = ""
            (when shouldRestart (funcall spawnServer)))
        (printf "ignoring stale server finish callback with code %L\n" exitStatus))))

  (defglobalfun pyStartServer
    (@key (id "default") (logLevel "INFO") (singleMode nil)
          (timeout nil) (python "python") (forceTcp nil) "ttggtg")
    (if _state->ipc
        (progn
          (fprintf _stderr "server is already running\n")
          nil)
      (progn
        _state->id = id
        _state->logLevel = logLevel
        _state->singleMode = singleMode
        _state->timeout = timeout
        _state->python = python
        _state->forceTcp = forceTcp
        _state->restartPending = nil
        (funcall spawnServer))))

  (defglobalfun pyKillServer ()
    (if (not _state->ipc)
        (progn
          (printf "server was not running\n")
          nil)
      (progn
        _state->restartPending = nil
        (__pyIpcKillProcess _state->ipc)
        t)))

  (defglobalfun pyRestartServer ()
    (if (not _state->ipc)
        (funcall spawnServer)
      (progn
        _state->restartPending = t
        (if (equal _state->requestIpc _state->ipc)
            t
          (progn
            (__pyIpcKillProcess _state->ipc)
            t)))))

  (defglobalfun pyReloadScript ()
    (printf "killing the old server\n")
    _state->acceptData = nil
    (pyKillServer)
    (load _filename)
    t)

  (defglobalfun pyShowLog (@optional (length 20) "x")
    (if (or (not (fixp length)) (lessp length 1))
        (progn
          (fprintf _stderr "pyShowLog: length must be a positive integer\n")
          nil)
      (let ((fin nil) line (lines declare(lines[length])) (ptr 0)
            (count 0) (start 0) i)
        (setq fin (infile _serverLogName))
        (if (not fin)
            (progn
              (fprintf _stderr "pyShowLog: cannot open log file %s\n" _serverLogName)
              nil)
          (progn
            (unwindProtect
              (while (gets line fin)
                lines[ptr] = line
                ptr = mod(ptr + 1 length)
                (when (lessp count length)
                  count = count + 1))
              (close fin))
            (if (lessp count length)
                (setq start 0)
              (setq start ptr))
            (when (greaterp count 0)
              (for i 0 count-1
                (printf "%s" lines[mod(start + i length)])))
            (printf "")
            t)))))

  (defglobalfun pyRunScript
    (script @key (python "") (args nil) (block nil) "ttlg")
    (let ((effectivePython nil) (command nil) process oldPythonPath
          (active t) (buffer "") dataHandler finishHandler)
      (setq effectivePython
        (if (equal python "") then _state->python else python))
      (setq command
        (lsprintf "\"%s\" -m allegrobridge._kernel._run_script \"%s\""
                  effectivePython script))
      (when args
        (setq command (lsprintf "%s %s" command (buildString args))))
      (setq dataHandler
        (lambda (id data)
          (when (and active (equal id process))
            (let ((fed nil) line evaluation completed boundResult result
                  outerError capturedWarning pythonCode)
              (setq fed (funcall feedLines buffer data))
              (setq buffer (car fed))
              (foreach line (cadr fed)
                (setq evaluation (funcall evaluateLine line))
                (setq completed (car evaluation))
                (setq boundResult (cadr evaluation))
                (setq result (caddr evaluation))
                (setq outerError (cadddr evaluation))
                (setq capturedWarning (nth 4 evaluation))
                (if boundResult
                    (if completed
                        (progn
                          (setq pythonCode (funcall skillToPython result))
                          (when (and (not (equal capturedWarning ""))
                                     (not (equal capturedWarning "*WARNING* ")))
                            (setq pythonCode
                              (lsprintf "warning(%L, %s)"
                                        capturedWarning pythonCode)))
                          (__pyIpcWriteProcess id
                            (lsprintf "success %s\n" pythonCode)))
                      (__pyIpcWriteProcess id
                        (lsprintf "failure %L\n" outerError)))
                  (__pyIpcWriteProcess id "success error('unbound')\n")))))))
      (setq finishHandler
        (lambda (id exitStatus)
          (when (equal id process)
            (setq active nil)
            (setq buffer "")
            (printf "script finished with code %L\n" exitStatus))))
      (setq oldPythonPath (getShellEnvVar "PYTHONPATH"))
      (setq process
        (unwindProtect
          (progn
            (setShellEnvVar "PYTHONPATH" _moduleFolder)
            (__pyIpcBeginProcess command "" dataHandler onError finishHandler _scriptLogName))
          (if oldPythonPath
              (setShellEnvVar "PYTHONPATH" oldPythonPath)
            (unsetShellEnvVar "PYTHONPATH"))))
      (if block
          (__pyIpcWait process)
        process)))

  _state->ipc = nil
  _state->id = "default"
  _state->logLevel = "INFO"
  _state->singleMode = nil
  _state->timeout = nil
  _state->python = "python"
  _state->forceTcp = nil
  _state->restartPending = nil
  _state->requestIpc = nil
  _state->receiveBuffer = ""
  _state->acceptData = nil

  (printf "Available commands:\n")
  (printf "\tpyStartServer ?id \"default\" ?logLevel \"WARNING\" ?singleMode nil ?timeout nil ?python \"python\" ?forceTcp nil\n")
  (printf "\tpyKillServer\n")
  (printf "\tpyRestartServer\n")
  (printf "\tpyReloadScript\n")
  (printf "\tpyShowLog [numberOfLines]\n")
  (printf "\tpyRunScript path ?args list() ?python \"python\"\n")

  (foreach _oldName
    '(__pyCaptureWarnings __pyListToPython __pyOnData __pyOnDataScript
      __pyOnError __pyOnFinish __pyOnFinishScript __pyPropertyListToPython
      __pySaveToVariableAndReturn __pySkillToPython __pySpawnServer
      __pyStableRemoteVariable __pyTableToPython __pyVectorToPython __pyWriteFrame)
    (putd _oldName nil))
  (foreach _oldProperty
    '((pyStartServer ipc) (pyStartServer id) (pyStartServer logLevel)
      (pyStartServer singleMode) (pyStartServer timeout) (pyStartServer python)
      (pyStartServer forceTcp) (pyStartServer restartPending)
      (pyStartServer requestIpc) (pyStartServer receiveBuffer) (pyStartServer state)
      (pyStartServer moduleFolder) (pyStartServer logName)
      (pyRunScript logName) (pyShowLog logName) (pyReloadServer filename)
      (__pyStableRemoteVariable Registry)
      (__pyWriteFrame STX) (__pyWriteFrame NAK) (__pyWriteFrame RST)
      (__pyWriteFrame ESC) (__pyWriteFrame RS) (__pyWriteFrame ESCPattern)
      (__pyWriteFrame RSPattern))
    (remprop (car _oldProperty) (cadr _oldProperty)))
)
