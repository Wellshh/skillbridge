;; Auto-generated by write_geometry_il.py
;; Import nets (via + path) from pcb_geometry.json into Allegro .brd

axlCmdRegister("import_pcb_geometry" 'import_pcb_geometry ?cmdType "interactive" ?undo t)

(defun import_pcb_geometry ()
  let((path myvia)
    ;; ===== net: SPK_OUT_P =====
    path = axlPathStart( (list 17.4599:18.3548))
    axlPathLine( path, 0.5, 17.4598:14.9248 )
    axlPathArcCenter( path, 0.5, 16.2273:12.8104, t, 15.03:14.9248 )
    axlPathArcCenter( path, 0.5, 14.4298:9.7114, nil, 18.0001:9.7114 )
    axlPathLine( path, 0.5, 14.4298:-69.9567 )
    axlPathArcCenter( path, 0.5, 14.3823:-70.4347, t, 12.0007:-69.9567 )
    axlPathArcCenter( path, 0.5, 14.3326:-70.6373, t, 11.9986:-69.957 )
    axlPathArcCenter( path, 0.5, 13.8765:-71.5002, t, 12.0001:-69.9565 )
    axlPathLine( path, 0.5, 8.4653:-78.0924 )
    axlPathArcCenter( path, 0.5, 7.6598:-80.3514, nil, 11.2302:-80.3514 )
    axlPathLine( path, 0.5, 7.6598:-87.474 )
    axlPathArcCenter( path, 0.5, 7.3288:-88.6983, t, 5.23:-87.474 )
    axlPathLine( path, 0.5, 7.0751:-89.1377 )
    axlPathLine( path, 0.5, 6.9216:-89.3887 )
    axlPathArcCenter( path, 0.5, 6.7663:-89.654, nil, 16.0307:-94.8979 )
    axlPathArcCenter( path, 0.5, 6.6101:-89.9473, nil, 12.3748:-92.8305 )
    axlPathArcCenter( path, 0.5, 6.4988:-90.1882, nil, 10.7699:-92.0158 )
    axlPathArcCenter( path, 0.5, 6.3956:-90.458, nil, 9.8695:-91.6312 )
    axlPathArcCenter( path, 0.5, 6.3272:-90.6909, nil, 9.3294:-91.4479 )
    axlPathArcCenter( path, 0.5, 6.2459:-91.2505, nil, 8.9068:-91.3512 )
    axlPathLine( path, 0.5, 6.16:-94.0967 )
    axlPathArcCenter( path, 0.5, 6.1317:-94.302, t, 5.1239:-94.0583 )
    axlPathArcCenter( path, 0.5, 6.1072:-94.392, t, 4.8135:-93.9925 )
    axlPathArcCenter( path, 0.5, 6.066:-94.5105, t, 4.4288:-93.8736 )
    axlPathArcCenter( path, 0.5, 6.0193:-94.6224, t, 3.7479:-93.608 )
    axlPathArcCenter( path, 0.5, 5.9415:-94.7847, t, 2.5637:-93.0665 )
    axlPathArcCenter( path, 0.5, 5.8626:-94.9352, t, -0.0826:-91.7202 )
    axlPathLine( path, 0.5, 5.7719:-95.101 )
    axlPathLine( path, 0.5, 5.1742:-96.1364 )
    axlPathArcCenter( path, 0.5, 4.8298:-97.4216, nil, 7.4:-97.4216 )
    axlPathLine( path, 0.5, 4.8298:-97.7114 )
    axlDBCreatePath( path, "ETCH/TOP", "SPK_OUT_P")

    ;; ===== net: SPK_OUT_M =====
    path = axlPathStart( (list 17.4599:18.8299))
    axlPathLine( path, 0.5, 17.4598:14.9248 )
    axlPathArcCenter( path, 0.5, 16.2273:12.8104, t, 15.03:14.9248 )
    axlPathArcCenter( path, 0.5, 14.4298:9.7114, nil, 18.0001:9.7114 )
    axlPathLine( path, 0.5, 14.4298:-69.9567 )
    axlPathArcCenter( path, 0.5, 14.3823:-70.4347, t, 12.0007:-69.9567 )
    axlPathArcCenter( path, 0.5, 14.3326:-70.6373, t, 11.9986:-69.957 )
    axlPathArcCenter( path, 0.5, 13.8765:-71.5002, t, 12.0001:-69.9565 )
    axlPathLine( path, 0.5, 8.4653:-78.0924 )
    axlPathArcCenter( path, 0.5, 7.6598:-80.3514, nil, 11.2302:-80.3514 )
    axlPathLine( path, 0.5, 7.6598:-87.474 )
    axlPathArcCenter( path, 0.5, 7.3288:-88.6983, t, 5.23:-87.474 )
    axlPathLine( path, 0.5, 7.0751:-89.1377 )
    axlPathLine( path, 0.5, 6.9216:-89.3887 )
    axlPathArcCenter( path, 0.5, 6.7663:-89.654, nil, 16.0307:-94.8979 )
    axlPathArcCenter( path, 0.5, 6.6101:-89.9473, nil, 12.3748:-92.8305 )
    axlPathArcCenter( path, 0.5, 6.4988:-90.1882, nil, 10.7699:-92.0158 )
    axlPathArcCenter( path, 0.5, 6.3956:-90.458, nil, 9.8695:-91.6312 )
    axlPathArcCenter( path, 0.5, 6.3272:-90.6909, nil, 9.3294:-91.4479 )
    axlPathArcCenter( path, 0.5, 6.2459:-91.2505, nil, 8.9068:-91.3512 )
    axlPathLine( path, 0.5, 6.16:-94.0967 )
    axlPathArcCenter( path, 0.5, 6.1317:-94.302, t, 5.1239:-94.0583 )
    axlPathArcCenter( path, 0.5, 6.1072:-94.392, t, 4.8135:-93.9925 )
    axlPathArcCenter( path, 0.5, 6.066:-94.5105, t, 4.4288:-93.8736 )
    axlPathArcCenter( path, 0.5, 6.0193:-94.6224, t, 3.7479:-93.608 )
    axlPathArcCenter( path, 0.5, 5.9415:-94.7847, t, 2.5637:-93.0665 )
    axlPathArcCenter( path, 0.5, 5.8626:-94.9352, t, -0.0826:-91.7202 )
    axlPathLine( path, 0.5, 5.7719:-95.101 )
    axlPathLine( path, 0.5, 5.1742:-96.1364 )
    axlPathArcCenter( path, 0.5, 4.8298:-97.4216, nil, 7.4:-97.4216 )
    axlPathLine( path, 0.5, 4.8298:-97.7114 )
    axlDBCreatePath( path, "ETCH/BOTTOM", "SPK_OUT_M")

    ;; ===== net: GND =====
    path = axlPathStart( (list 17.1199:18.3548))
    axlPathLine( path, 0.06, 17.1198:14.9248 )
    axlPathArcCenter( path, 0.06, 16.0591:13.106, t, 15.03:14.9248 )
    axlPathArcCenter( path, 0.06, 14.0898:9.7114, nil, 18.0001:9.7114 )
    axlPathLine( path, 0.06, 14.0898:-69.9567 )
    axlPathArcCenter( path, 0.06, 14.0489:-70.3679, t, 12.0007:-69.9567 )
    axlPathArcCenter( path, 0.06, 14.0062:-70.5421, t, 11.9986:-69.957 )
    axlPathArcCenter( path, 0.06, 13.6138:-71.2843, t, 12.0001:-69.9565 )
    axlPathLine( path, 0.06, 8.2023:-77.8769 )
    axlPathArcCenter( path, 0.06, 7.3198:-80.3514, nil, 11.2302:-80.3514 )
    axlPathLine( path, 0.06, 7.3198:-87.474 )
    axlPathArcCenter( path, 0.06, 7.0348:-88.5276, t, 5.23:-87.474 )
    axlPathLine( path, 0.06, 6.7828:-88.964 )
    axlPathLine( path, 0.06, 6.6312:-89.212 )
    axlPathArcCenter( path, 0.06, 6.4704:-89.4866, nil, 16.0307:-94.8979 )
    axlPathArcCenter( path, 0.06, 6.3059:-89.7956, nil, 12.3748:-92.8305 )
    axlPathArcCenter( path, 0.06, 6.1862:-90.0544, nil, 10.7699:-92.0158 )
    axlPathArcCenter( path, 0.06, 6.0735:-90.3493, nil, 9.8695:-91.6312 )
    axlPathArcCenter( path, 0.06, 5.9976:-90.6072, nil, 9.3294:-91.4479 )
    axlPathArcCenter( path, 0.06, 5.9061:-91.239, nil, 8.9068:-91.3512 )
    axlPathLine( path, 0.06, 5.8202:-94.0852 )
    axlPathArcCenter( path, 0.06, 5.8009:-94.2231, t, 5.1239:-94.0583 )
    axlPathArcCenter( path, 0.06, 5.7824:-94.2917, t, 4.8135:-93.9925 )
    axlPathArcCenter( path, 0.06, 5.7491:-94.3872, t, 4.4288:-93.8736 )
    axlPathArcCenter( path, 0.06, 5.709:-94.4833, t, 3.7479:-93.608 )
    axlPathArcCenter( path, 0.06, 5.6385:-94.6305, t, 2.5637:-93.0665 )
    axlPathArcCenter( path, 0.06, 5.5639:-94.7727, t, -0.0826:-91.7202 )
    axlPathLine( path, 0.06, 5.4755:-94.9344 )
    axlPathLine( path, 0.06, 4.8797:-95.9665 )
    axlPathArcCenter( path, 0.06, 4.4898:-97.4216, nil, 7.4:-97.4216 )
    axlPathLine( path, 0.06, 4.4898:-97.7114 )
    axlDBCreatePath( path, "ETCH/TOP", "GND")

    path = axlPathStart( (list 17.1199:18.8299))
    axlPathLine( path, 0.06, 17.1198:14.9248 )
    axlPathArcCenter( path, 0.06, 16.0591:13.106, t, 15.03:14.9248 )
    axlPathArcCenter( path, 0.06, 14.0898:9.7114, nil, 18.0001:9.7114 )
    axlPathLine( path, 0.06, 14.0898:-69.9567 )
    axlPathArcCenter( path, 0.06, 14.0489:-70.3679, t, 12.0007:-69.9567 )
    axlPathArcCenter( path, 0.06, 14.0062:-70.5421, t, 11.9986:-69.957 )
    axlPathArcCenter( path, 0.06, 13.6138:-71.2843, t, 12.0001:-69.9565 )
    axlPathLine( path, 0.06, 8.2023:-77.8769 )
    axlPathArcCenter( path, 0.06, 7.3198:-80.3514, nil, 11.2302:-80.3514 )
    axlPathLine( path, 0.06, 7.3198:-87.474 )
    axlPathArcCenter( path, 0.06, 7.0348:-88.5276, t, 5.23:-87.474 )
    axlPathLine( path, 0.06, 6.7828:-88.964 )
    axlPathLine( path, 0.06, 6.6312:-89.212 )
    axlPathArcCenter( path, 0.06, 6.4704:-89.4866, nil, 16.0307:-94.8979 )
    axlPathArcCenter( path, 0.06, 6.3059:-89.7956, nil, 12.3748:-92.8305 )
    axlPathArcCenter( path, 0.06, 6.1862:-90.0544, nil, 10.7699:-92.0158 )
    axlPathArcCenter( path, 0.06, 6.0735:-90.3493, nil, 9.8695:-91.6312 )
    axlPathArcCenter( path, 0.06, 5.9976:-90.6072, nil, 9.3294:-91.4479 )
    axlPathArcCenter( path, 0.06, 5.9061:-91.239, nil, 8.9068:-91.3512 )
    axlPathLine( path, 0.06, 5.8202:-94.0852 )
    axlPathArcCenter( path, 0.06, 5.8009:-94.2231, t, 5.1239:-94.0583 )
    axlPathArcCenter( path, 0.06, 5.7824:-94.2917, t, 4.8135:-93.9925 )
    axlPathArcCenter( path, 0.06, 5.7491:-94.3872, t, 4.4288:-93.8736 )
    axlPathArcCenter( path, 0.06, 5.709:-94.4833, t, 3.7479:-93.608 )
    axlPathArcCenter( path, 0.06, 5.6385:-94.6305, t, 2.5637:-93.0665 )
    axlPathArcCenter( path, 0.06, 5.5639:-94.7727, t, -0.0826:-91.7202 )
    axlPathLine( path, 0.06, 5.4755:-94.9344 )
    axlPathLine( path, 0.06, 4.8797:-95.9665 )
    axlPathArcCenter( path, 0.06, 4.4898:-97.4216, nil, 7.4:-97.4216 )
    axlPathLine( path, 0.06, 4.4898:-97.7114 )
    axlDBCreatePath( path, "ETCH/BOTTOM", "GND")

    path = axlPathStart( (list 16.8799:18.3548))
    axlPathLine( path, 0.06, 16.8798:14.9248 )
    axlPathArcCenter( path, 0.06, 15.9405:13.3146, t, 15.03:14.9248 )
    axlPathArcCenter( path, 0.06, 13.8498:9.7114, nil, 18.0001:9.7114 )
    axlPathLine( path, 0.06, 13.8498:-69.9567 )
    axlPathArcCenter( path, 0.06, 13.8136:-70.3207, t, 12.0007:-69.9567 )
    axlPathArcCenter( path, 0.06, 13.7758:-70.4749, t, 11.9986:-69.957 )
    axlPathArcCenter( path, 0.06, 13.4284:-71.132, t, 12.0001:-69.9565 )
    axlPathLine( path, 0.06, 8.0166:-77.7248 )
    axlPathArcCenter( path, 0.06, 7.0798:-80.3514, nil, 11.2302:-80.3514 )
    axlPathLine( path, 0.06, 7.0798:-87.474 )
    axlPathArcCenter( path, 0.06, 6.8272:-88.4071, t, 5.23:-87.474 )
    axlPathLine( path, 0.06, 6.5765:-88.8414 )
    axlPathLine( path, 0.06, 6.4261:-89.0872 )
    axlPathArcCenter( path, 0.06, 6.2616:-89.3683, nil, 16.0307:-94.8979 )
    axlPathArcCenter( path, 0.06, 6.0911:-89.6884, nil, 12.3748:-92.8305 )
    axlPathArcCenter( path, 0.06, 5.9656:-89.9599, nil, 10.7699:-92.0158 )
    axlPathArcCenter( path, 0.06, 5.8461:-90.2725, nil, 9.8695:-91.6312 )
    axlPathArcCenter( path, 0.06, 5.765:-90.5481, nil, 9.3294:-91.4479 )
    axlPathArcCenter( path, 0.06, 5.6662:-91.2309, nil, 8.9068:-91.3512 )
    axlPathLine( path, 0.06, 5.5803:-94.0768 )
    axlPathArcCenter( path, 0.06, 5.5675:-94.1674, t, 5.1239:-94.0583 )
    axlPathArcCenter( path, 0.06, 5.553:-94.2209, t, 4.8135:-93.9925 )
    axlPathArcCenter( path, 0.06, 5.5254:-94.3002, t, 4.4288:-93.8736 )
    axlPathArcCenter( path, 0.06, 5.49:-94.3851, t, 3.7479:-93.608 )
    axlPathArcCenter( path, 0.06, 5.4246:-94.5217, t, 2.5637:-93.0665 )
    axlPathArcCenter( path, 0.06, 5.3531:-94.6581, t, -0.0826:-91.7202 )
    axlPathLine( path, 0.06, 5.2662:-94.8168 )
    axlPathLine( path, 0.06, 4.6719:-95.8465 )
    axlPathArcCenter( path, 0.06, 4.2498:-97.4216, nil, 7.4:-97.4216 )
    axlPathLine( path, 0.06, 4.2498:-97.7114 )
    axlDBCreatePath( path, "ETCH/TOP", "GND")

    path = axlPathStart( (list 16.8799:18.8299))
    axlPathLine( path, 0.06, 16.8798:14.9248 )
    axlPathArcCenter( path, 0.06, 15.9405:13.3146, t, 15.03:14.9248 )
    axlPathArcCenter( path, 0.06, 13.8498:9.7114, nil, 18.0001:9.7114 )
    axlPathLine( path, 0.06, 13.8498:-69.9567 )
    axlPathArcCenter( path, 0.06, 13.8136:-70.3207, t, 12.0007:-69.9567 )
    axlPathArcCenter( path, 0.06, 13.7758:-70.4749, t, 11.9986:-69.957 )
    axlPathArcCenter( path, 0.06, 13.4284:-71.132, t, 12.0001:-69.9565 )
    axlPathLine( path, 0.06, 8.0166:-77.7248 )
    axlPathArcCenter( path, 0.06, 7.0798:-80.3514, nil, 11.2302:-80.3514 )
    axlPathLine( path, 0.06, 7.0798:-87.474 )
    axlPathArcCenter( path, 0.06, 6.8272:-88.4071, t, 5.23:-87.474 )
    axlPathLine( path, 0.06, 6.5765:-88.8414 )
    axlPathLine( path, 0.06, 6.4261:-89.0872 )
    axlPathArcCenter( path, 0.06, 6.2616:-89.3683, nil, 16.0307:-94.8979 )
    axlPathArcCenter( path, 0.06, 6.0911:-89.6884, nil, 12.3748:-92.8305 )
    axlPathArcCenter( path, 0.06, 5.9656:-89.9599, nil, 10.7699:-92.0158 )
    axlPathArcCenter( path, 0.06, 5.8461:-90.2725, nil, 9.8695:-91.6312 )
    axlPathArcCenter( path, 0.06, 5.765:-90.5481, nil, 9.3294:-91.4479 )
    axlPathArcCenter( path, 0.06, 5.6662:-91.2309, nil, 8.9068:-91.3512 )
    axlPathLine( path, 0.06, 5.5803:-94.0768 )
    axlPathArcCenter( path, 0.06, 5.5675:-94.1674, t, 5.1239:-94.0583 )
    axlPathArcCenter( path, 0.06, 5.553:-94.2209, t, 4.8135:-93.9925 )
    axlPathArcCenter( path, 0.06, 5.5254:-94.3002, t, 4.4288:-93.8736 )
    axlPathArcCenter( path, 0.06, 5.49:-94.3851, t, 3.7479:-93.608 )
    axlPathArcCenter( path, 0.06, 5.4246:-94.5217, t, 2.5637:-93.0665 )
    axlPathArcCenter( path, 0.06, 5.3531:-94.6581, t, -0.0826:-91.7202 )
    axlPathLine( path, 0.06, 5.2662:-94.8168 )
    axlPathLine( path, 0.06, 4.6719:-95.8465 )
    axlPathArcCenter( path, 0.06, 4.2498:-97.4216, nil, 7.4:-97.4216 )
    axlPathLine( path, 0.06, 4.2498:-97.7114 )
    axlDBCreatePath( path, "ETCH/BOTTOM", "GND")

    path = axlPathStart( (list 16.3999:18.3548))
    axlPathLine( path, 0.06, 16.3997:14.9248 )
    axlPathArcCenter( path, 0.06, 15.7033:13.732, t, 15.03:14.9248 )
    axlPathArcCenter( path, 0.06, 13.3697:9.7114, nil, 18.0001:9.7114 )
    axlPathLine( path, 0.06, 13.3697:-69.9567 )
    axlPathArcCenter( path, 0.06, 13.3429:-70.2263, t, 12.0007:-69.9567 )
    axlPathArcCenter( path, 0.06, 13.3149:-70.3404, t, 11.9986:-69.957 )
    axlPathArcCenter( path, 0.06, 13.0575:-70.8271, t, 12.0001:-69.9565 )
    axlPathLine( path, 0.06, 7.6452:-77.4206 )
    axlPathArcCenter( path, 0.06, 6.5997:-80.3514, nil, 11.2302:-80.3514 )
    axlPathLine( path, 0.06, 6.5997:-87.474 )
    axlPathArcCenter( path, 0.06, 6.4121:-88.1659, t, 5.23:-87.474 )
    axlPathLine( path, 0.06, 6.1638:-88.5961 )
    axlPathLine( path, 0.06, 6.016:-88.8377 )
    axlPathArcCenter( path, 0.06, 5.8438:-89.1318, nil, 16.0307:-94.8979 )
    axlPathArcCenter( path, 0.06, 5.6614:-89.4742, nil, 12.3748:-92.8305 )
    axlPathArcCenter( path, 0.06, 5.5242:-89.771, nil, 10.7699:-92.0158 )
    axlPathArcCenter( path, 0.06, 5.3913:-90.1189, nil, 9.8695:-91.6312 )
    axlPathArcCenter( path, 0.06, 5.2997:-90.4299, nil, 9.3294:-91.4479 )
    axlPathArcCenter( path, 0.06, 5.1864:-91.2148, nil, 8.9068:-91.3512 )
    axlPathLine( path, 0.06, 5.1007:-94.0551 )
    axlPathArcCenter( path, 0.06, 5.0943:-94.0792, t, 4.8135:-93.9925 )
    axlPathArcCenter( path, 0.06, 5.078:-94.1261, t, 4.4288:-93.8736 )
    axlPathArcCenter( path, 0.06, 5.0519:-94.1887, t, 3.7479:-93.608 )
    axlPathArcCenter( path, 0.06, 4.9966:-94.304, t, 2.5637:-93.0665 )
    axlPathArcCenter( path, 0.06, 4.9313:-94.4287, t, -0.0826:-91.7202 )
    axlPathLine( path, 0.06, 4.8477:-94.5815 )
    axlPathLine( path, 0.06, 4.2561:-95.6065 )
    axlPathArcCenter( path, 0.06, 3.7697:-97.4216, nil, 7.4:-97.4216 )
    axlPathLine( path, 0.06, 3.7697:-97.7114 )
    axlDBCreatePath( path, "ETCH/TOP", "GND")

    path = axlPathStart( (list 16.3999:18.8299))
    axlPathLine( path, 0.06, 16.3997:14.9248 )
    axlPathArcCenter( path, 0.06, 15.7033:13.732, t, 15.03:14.9248 )
    axlPathArcCenter( path, 0.06, 13.3697:9.7114, nil, 18.0001:9.7114 )
    axlPathLine( path, 0.06, 13.3697:-69.9567 )
    axlPathArcCenter( path, 0.06, 13.3429:-70.2263, t, 12.0007:-69.9567 )
    axlPathArcCenter( path, 0.06, 13.3149:-70.3404, t, 11.9986:-69.957 )
    axlPathArcCenter( path, 0.06, 13.0575:-70.8271, t, 12.0001:-69.9565 )
    axlPathLine( path, 0.06, 7.6452:-77.4206 )
    axlPathArcCenter( path, 0.06, 6.5997:-80.3514, nil, 11.2302:-80.3514 )
    axlPathLine( path, 0.06, 6.5997:-87.474 )
    axlPathArcCenter( path, 0.06, 6.4121:-88.1659, t, 5.23:-87.474 )
    axlPathLine( path, 0.06, 6.1638:-88.5961 )
    axlPathLine( path, 0.06, 6.016:-88.8377 )
    axlPathArcCenter( path, 0.06, 5.8438:-89.1318, nil, 16.0307:-94.8979 )
    axlPathArcCenter( path, 0.06, 5.6614:-89.4742, nil, 12.3748:-92.8305 )
    axlPathArcCenter( path, 0.06, 5.5242:-89.771, nil, 10.7699:-92.0158 )
    axlPathArcCenter( path, 0.06, 5.3913:-90.1189, nil, 9.8695:-91.6312 )
    axlPathArcCenter( path, 0.06, 5.2997:-90.4299, nil, 9.3294:-91.4479 )
    axlPathArcCenter( path, 0.06, 5.1864:-91.2148, nil, 8.9068:-91.3512 )
    axlPathLine( path, 0.06, 5.1007:-94.0551 )
    axlPathArcCenter( path, 0.06, 5.0943:-94.0792, t, 4.8135:-93.9925 )
    axlPathArcCenter( path, 0.06, 5.078:-94.1261, t, 4.4288:-93.8736 )
    axlPathArcCenter( path, 0.06, 5.0519:-94.1887, t, 3.7479:-93.608 )
    axlPathArcCenter( path, 0.06, 4.9966:-94.304, t, 2.5637:-93.0665 )
    axlPathArcCenter( path, 0.06, 4.9313:-94.4287, t, -0.0826:-91.7202 )
    axlPathLine( path, 0.06, 4.8477:-94.5815 )
    axlPathLine( path, 0.06, 4.2561:-95.6065 )
    axlPathArcCenter( path, 0.06, 3.7697:-97.4216, nil, 7.4:-97.4216 )
    axlPathLine( path, 0.06, 3.7697:-97.7114 )
    axlDBCreatePath( path, "ETCH/BOTTOM", "GND")

    path = axlPathStart( (list 15.9199:18.3548))
    axlPathLine( path, 0.06, 15.9197:14.9248 )
    axlPathArcCenter( path, 0.06, 15.4664:14.1495, t, 15.03:14.9248 )
    axlPathArcCenter( path, 0.06, 12.8897:9.7114, nil, 18.0001:9.7114 )
    axlPathLine( path, 0.06, 12.8897:-69.9567 )
    axlPathArcCenter( path, 0.06, 12.8723:-70.1319, t, 12.0007:-69.9567 )
    axlPathArcCenter( path, 0.06, 12.8541:-70.206, t, 11.9986:-69.957 )
    axlPathArcCenter( path, 0.06, 12.6868:-70.5222, t, 12.0001:-69.9565 )
    axlPathLine( path, 0.06, 7.2739:-77.1164 )
    axlPathArcCenter( path, 0.06, 6.1197:-80.3514, nil, 11.2302:-80.3514 )
    axlPathLine( path, 0.06, 6.1197:-87.474 )
    axlPathArcCenter( path, 0.06, 5.9972:-87.9246, t, 5.23:-87.474 )
    axlPathLine( path, 0.06, 5.7511:-88.3508 )
    axlPathLine( path, 0.06, 5.6059:-88.5882 )
    axlPathArcCenter( path, 0.06, 5.426:-88.8954, nil, 16.0307:-94.8979 )
    axlPathArcCenter( path, 0.06, 5.2319:-89.2599, nil, 12.3748:-92.8305 )
    axlPathArcCenter( path, 0.06, 5.0829:-89.5822, nil, 10.7699:-92.0158 )
    axlPathArcCenter( path, 0.06, 4.9365:-89.9653, nil, 9.8695:-91.6312 )
    axlPathArcCenter( path, 0.06, 4.8345:-90.3118, nil, 9.3294:-91.4479 )
    axlPathArcCenter( path, 0.06, 4.7067:-91.1989, nil, 8.9068:-91.3512 )
    axlPathLine( path, 0.06, 4.623:-93.9713 )
    axlPathArcCenter( path, 0.06, 4.6139:-93.9925, t, 3.7479:-93.608 )
    axlPathArcCenter( path, 0.06, 4.5688:-94.0864, t, 2.5637:-93.0665 )
    axlPathArcCenter( path, 0.06, 4.5096:-94.1995, t, -0.0826:-91.7202 )
    axlPathLine( path, 0.06, 4.4292:-94.3463 )
    axlPathLine( path, 0.06, 3.8403:-95.3665 )
    axlPathArcCenter( path, 0.06, 3.2897:-97.4216, nil, 7.4:-97.4216 )
    axlPathLine( path, 0.06, 3.2897:-97.7114 )
    axlDBCreatePath( path, "ETCH/TOP", "GND")

    path = axlPathStart( (list 15.9199:18.8299))
    axlPathLine( path, 0.06, 15.9197:14.9248 )
    axlPathArcCenter( path, 0.06, 15.4664:14.1495, t, 15.03:14.9248 )
    axlPathArcCenter( path, 0.06, 12.8897:9.7114, nil, 18.0001:9.7114 )
    axlPathLine( path, 0.06, 12.8897:-69.9567 )
    axlPathArcCenter( path, 0.06, 12.8723:-70.1319, t, 12.0007:-69.9567 )
    axlPathArcCenter( path, 0.06, 12.8541:-70.206, t, 11.9986:-69.957 )
    axlPathArcCenter( path, 0.06, 12.6868:-70.5222, t, 12.0001:-69.9565 )
    axlPathLine( path, 0.06, 7.2739:-77.1164 )
    axlPathArcCenter( path, 0.06, 6.1197:-80.3514, nil, 11.2302:-80.3514 )
    axlPathLine( path, 0.06, 6.1197:-87.474 )
    axlPathArcCenter( path, 0.06, 5.9972:-87.9246, t, 5.23:-87.474 )
    axlPathLine( path, 0.06, 5.7511:-88.3508 )
    axlPathLine( path, 0.06, 5.6059:-88.5882 )
    axlPathArcCenter( path, 0.06, 5.426:-88.8954, nil, 16.0307:-94.8979 )
    axlPathArcCenter( path, 0.06, 5.2319:-89.2599, nil, 12.3748:-92.8305 )
    axlPathArcCenter( path, 0.06, 5.0829:-89.5822, nil, 10.7699:-92.0158 )
    axlPathArcCenter( path, 0.06, 4.9365:-89.9653, nil, 9.8695:-91.6312 )
    axlPathArcCenter( path, 0.06, 4.8345:-90.3118, nil, 9.3294:-91.4479 )
    axlPathArcCenter( path, 0.06, 4.7067:-91.1989, nil, 8.9068:-91.3512 )
    axlPathLine( path, 0.06, 4.623:-93.9713 )
    axlPathArcCenter( path, 0.06, 4.6139:-93.9925, t, 3.7479:-93.608 )
    axlPathArcCenter( path, 0.06, 4.5688:-94.0864, t, 2.5637:-93.0665 )
    axlPathArcCenter( path, 0.06, 4.5096:-94.1995, t, -0.0826:-91.7202 )
    axlPathLine( path, 0.06, 4.4292:-94.3463 )
    axlPathLine( path, 0.06, 3.8403:-95.3665 )
    axlPathArcCenter( path, 0.06, 3.2897:-97.4216, nil, 7.4:-97.4216 )
    axlPathLine( path, 0.06, 3.2897:-97.7114 )
    axlDBCreatePath( path, "ETCH/BOTTOM", "GND")

    path = axlPathStart( (list 15.5599:18.3548))
    axlPathLine( path, 0.06, 15.5597:14.9248 )
    axlPathArcCenter( path, 0.06, 15.289:14.4627, t, 15.03:14.9248 )
    axlPathArcCenter( path, 0.06, 12.5297:9.7114, nil, 18.0001:9.7114 )
    axlPathLine( path, 0.06, 12.5297:-69.9567 )
    axlPathArcCenter( path, 0.06, 12.5193:-70.0611, t, 12.0007:-69.9567 )
    axlPathArcCenter( path, 0.06, 12.5085:-70.1052, t, 11.9986:-69.957 )
    axlPathArcCenter( path, 0.06, 12.4087:-70.2936, t, 12.0001:-69.9565 )
    axlPathLine( path, 0.06, 6.9954:-76.8883 )
    axlPathArcCenter( path, 0.06, 5.7597:-80.3514, nil, 11.2302:-80.3514 )
    axlPathLine( path, 0.06, 5.7597:-87.474 )
    axlPathArcCenter( path, 0.06, 5.6862:-87.7433, t, 5.23:-87.474 )
    axlPathLine( path, 0.06, 5.4416:-88.1668 )
    axlPathLine( path, 0.06, 5.2984:-88.401 )
    axlPathArcCenter( path, 0.06, 5.1127:-88.7181, nil, 16.0307:-94.8979 )
    axlPathArcCenter( path, 0.06, 4.9098:-89.0993, nil, 12.3748:-92.8305 )
    axlPathArcCenter( path, 0.06, 4.752:-89.4405, nil, 10.7699:-92.0158 )
    axlPathArcCenter( path, 0.06, 4.5954:-89.8501, nil, 9.8695:-91.6312 )
    axlPathArcCenter( path, 0.06, 4.4855:-90.2231, nil, 9.3294:-91.4479 )
    axlPathArcCenter( path, 0.06, 4.3469:-91.1869, nil, 8.9068:-91.3512 )
    axlPathLine( path, 0.06, 4.2653:-93.8881 )
    axlPathArcCenter( path, 0.06, 4.2479:-93.9232, t, 2.5637:-93.0665 )
    axlPathArcCenter( path, 0.06, 4.1933:-94.0276, t, -0.0826:-91.7202 )
    axlPathLine( path, 0.06, 4.1154:-94.1699 )
    axlPathLine( path, 0.06, 3.5286:-95.1865 )
    axlPathArcCenter( path, 0.06, 2.9297:-97.4216, nil, 7.4:-97.4216 )
    axlPathLine( path, 0.06, 2.9297:-97.7114 )
    axlDBCreatePath( path, "ETCH/TOP", "GND")

    path = axlPathStart( (list 15.5599:18.8299))
    axlPathLine( path, 0.06, 15.5597:14.9248 )
    axlPathArcCenter( path, 0.06, 15.289:14.4627, t, 15.03:14.9248 )
    axlPathArcCenter( path, 0.06, 12.5297:9.7114, nil, 18.0001:9.7114 )
    axlPathLine( path, 0.06, 12.5297:-69.9567 )
    axlPathArcCenter( path, 0.06, 12.5193:-70.0611, t, 12.0007:-69.9567 )
    axlPathArcCenter( path, 0.06, 12.5085:-70.1052, t, 11.9986:-69.957 )
    axlPathArcCenter( path, 0.06, 12.4087:-70.2936, t, 12.0001:-69.9565 )
    axlPathLine( path, 0.06, 6.9954:-76.8883 )
    axlPathArcCenter( path, 0.06, 5.7597:-80.3514, nil, 11.2302:-80.3514 )
    axlPathLine( path, 0.06, 5.7597:-87.474 )
    axlPathArcCenter( path, 0.06, 5.6862:-87.7433, t, 5.23:-87.474 )
    axlPathLine( path, 0.06, 5.4416:-88.1668 )
    axlPathLine( path, 0.06, 5.2984:-88.401 )
    axlPathArcCenter( path, 0.06, 5.1127:-88.7181, nil, 16.0307:-94.8979 )
    axlPathArcCenter( path, 0.06, 4.9098:-89.0993, nil, 12.3748:-92.8305 )
    axlPathArcCenter( path, 0.06, 4.752:-89.4405, nil, 10.7699:-92.0158 )
    axlPathArcCenter( path, 0.06, 4.5954:-89.8501, nil, 9.8695:-91.6312 )
    axlPathArcCenter( path, 0.06, 4.4855:-90.2231, nil, 9.3294:-91.4479 )
    axlPathArcCenter( path, 0.06, 4.3469:-91.1869, nil, 8.9068:-91.3512 )
    axlPathLine( path, 0.06, 4.2653:-93.8881 )
    axlPathArcCenter( path, 0.06, 4.2479:-93.9232, t, 2.5637:-93.0665 )
    axlPathArcCenter( path, 0.06, 4.1933:-94.0276, t, -0.0826:-91.7202 )
    axlPathLine( path, 0.06, 4.1154:-94.1699 )
    axlPathLine( path, 0.06, 3.5286:-95.1865 )
    axlPathArcCenter( path, 0.06, 2.9297:-97.4216, nil, 7.4:-97.4216 )
    axlPathLine( path, 0.06, 2.9297:-97.7114 )
    axlDBCreatePath( path, "ETCH/BOTTOM", "GND")

    path = axlPathStart( (list 14.9599:18.3548))
    axlPathLine( path, 0.06, 14.9597:14.9655 )
    axlPathArcCenter( path, 0.06, 11.9297:9.7114, nil, 18.0001:9.7114 )
    axlPathLine( path, 0.06, 11.9297:-69.9315 )
    axlPathLine( path, 0.06, 6.5313:-76.508 )
    axlPathArcCenter( path, 0.06, 5.1597:-80.3514, nil, 11.2302:-80.3514 )
    axlPathLine( path, 0.06, 5.1597:-87.4551 )
    axlPathLine( path, 0.06, 4.9258:-87.8602 )
    axlPathLine( path, 0.06, 4.7858:-88.0891 )
    axlPathArcCenter( path, 0.06, 4.5906:-88.4225, nil, 16.0307:-94.8979 )
    axlPathArcCenter( path, 0.06, 4.3728:-88.8315, nil, 12.3748:-92.8305 )
    axlPathArcCenter( path, 0.06, 4.2004:-89.2044, nil, 10.7699:-92.0158 )
    axlPathArcCenter( path, 0.06, 4.027:-89.6581, nil, 9.8695:-91.6312 )
    axlPathArcCenter( path, 0.06, 3.904:-90.0754, nil, 9.3294:-91.4479 )
    axlPathArcCenter( path, 0.06, 3.7472:-91.1671, nil, 8.9068:-91.3512 )
    axlPathLine( path, 0.06, 3.6697:-93.7344 )
    axlPathArcCenter( path, 0.06, 3.666:-93.7412, t, -0.0826:-91.7202 )
    axlPathLine( path, 0.06, 3.5923:-93.8759 )
    axlPathLine( path, 0.06, 3.0089:-94.8866 )
    axlPathArcCenter( path, 0.06, 2.3297:-97.4216, nil, 7.4:-97.4216 )
    axlPathLine( path, 0.06, 2.3297:-97.7114 )
    axlDBCreatePath( path, "ETCH/TOP", "GND")

    path = axlPathStart( (list 14.9599:18.8299))
    axlPathLine( path, 0.06, 14.9597:14.9655 )
    axlPathArcCenter( path, 0.06, 11.9297:9.7114, nil, 18.0001:9.7114 )
    axlPathLine( path, 0.06, 11.9297:-69.9315 )
    axlPathLine( path, 0.06, 6.5313:-76.508 )
    axlPathArcCenter( path, 0.06, 5.1597:-80.3514, nil, 11.2302:-80.3514 )
    axlPathLine( path, 0.06, 5.1597:-87.4551 )
    axlPathLine( path, 0.06, 4.9258:-87.8602 )
    axlPathLine( path, 0.06, 4.7858:-88.0891 )
    axlPathArcCenter( path, 0.06, 4.5906:-88.4225, nil, 16.0307:-94.8979 )
    axlPathArcCenter( path, 0.06, 4.3728:-88.8315, nil, 12.3748:-92.8305 )
    axlPathArcCenter( path, 0.06, 4.2004:-89.2044, nil, 10.7699:-92.0158 )
    axlPathArcCenter( path, 0.06, 4.027:-89.6581, nil, 9.8695:-91.6312 )
    axlPathArcCenter( path, 0.06, 3.904:-90.0754, nil, 9.3294:-91.4479 )
    axlPathArcCenter( path, 0.06, 3.7472:-91.1671, nil, 8.9068:-91.3512 )
    axlPathLine( path, 0.06, 3.6697:-93.7344 )
    axlPathArcCenter( path, 0.06, 3.666:-93.7412, t, -0.0826:-91.7202 )
    axlPathLine( path, 0.06, 3.5923:-93.8759 )
    axlPathLine( path, 0.06, 3.0089:-94.8866 )
    axlPathArcCenter( path, 0.06, 2.3297:-97.4216, nil, 7.4:-97.4216 )
    axlPathLine( path, 0.06, 2.3297:-97.7114 )
    axlDBCreatePath( path, "ETCH/BOTTOM", "GND")

    path = axlPathStart( (list 14.4299:18.3548))
    axlPathLine( path, 0.06, 14.4297:15.2628 )
    axlPathArcCenter( path, 0.06, 11.3997:9.7114, nil, 18.0001:9.7114 )
    axlPathLine( path, 0.06, 11.3997:-69.7418 )
    axlPathLine( path, 0.06, 6.1214:-76.1721 )
    axlPathArcCenter( path, 0.06, 4.6297:-80.3514, nil, 11.2302:-80.3514 )
    axlPathLine( path, 0.06, 4.6297:-87.3131 )
    axlPathLine( path, 0.06, 4.4702:-87.5894 )
    axlPathLine( path, 0.06, 4.3331:-87.8136 )
    axlPathArcCenter( path, 0.06, 4.1293:-88.1614, nil, 16.0307:-94.8979 )
    axlPathArcCenter( path, 0.06, 3.8986:-88.5949, nil, 12.3748:-92.8305 )
    axlPathArcCenter( path, 0.06, 3.7131:-88.9959, nil, 10.7699:-92.0158 )
    axlPathArcCenter( path, 0.06, 3.5248:-89.4885, nil, 9.8695:-91.6312 )
    axlPathArcCenter( path, 0.06, 3.3903:-89.945, nil, 9.3294:-91.4479 )
    axlPathArcCenter( path, 0.06, 3.2175:-91.1497, nil, 8.9068:-91.3512 )
    axlPathLine( path, 0.06, 3.1438:-93.5915 )
    axlPathLine( path, 0.06, 3.1303:-93.6162 )
    axlPathLine( path, 0.06, 2.5499:-94.6216 )
    axlPathArcCenter( path, 0.06, 1.7997:-97.4216, nil, 7.4:-97.4216 )
    axlPathLine( path, 0.06, 1.7997:-97.7114 )
    axlDBCreatePath( path, "ETCH/TOP", "GND")

    path = axlPathStart( (list 14.4299:18.8299))
    axlPathLine( path, 0.06, 14.4297:15.2628 )
    axlPathArcCenter( path, 0.06, 11.3997:9.7114, nil, 18.0001:9.7114 )
    axlPathLine( path, 0.06, 11.3997:-69.7418 )
    axlPathLine( path, 0.06, 6.1214:-76.1721 )
    axlPathArcCenter( path, 0.06, 4.6297:-80.3514, nil, 11.2302:-80.3514 )
    axlPathLine( path, 0.06, 4.6297:-87.3131 )
    axlPathLine( path, 0.06, 4.4702:-87.5894 )
    axlPathLine( path, 0.06, 4.3331:-87.8136 )
    axlPathArcCenter( path, 0.06, 4.1293:-88.1614, nil, 16.0307:-94.8979 )
    axlPathArcCenter( path, 0.06, 3.8986:-88.5949, nil, 12.3748:-92.8305 )
    axlPathArcCenter( path, 0.06, 3.7131:-88.9959, nil, 10.7699:-92.0158 )
    axlPathArcCenter( path, 0.06, 3.5248:-89.4885, nil, 9.8695:-91.6312 )
    axlPathArcCenter( path, 0.06, 3.3903:-89.945, nil, 9.3294:-91.4479 )
    axlPathArcCenter( path, 0.06, 3.2175:-91.1497, nil, 8.9068:-91.3512 )
    axlPathLine( path, 0.06, 3.1438:-93.5915 )
    axlPathLine( path, 0.06, 3.1303:-93.6162 )
    axlPathLine( path, 0.06, 2.5499:-94.6216 )
    axlPathArcCenter( path, 0.06, 1.7997:-97.4216, nil, 7.4:-97.4216 )
    axlPathLine( path, 0.06, 1.7997:-97.7114 )
    axlDBCreatePath( path, "ETCH/BOTTOM", "GND")

    path = axlPathStart( (list 14.0799:18.3548))
    axlPathLine( path, 0.06, 14.0796:15.4507 )
    axlPathArcCenter( path, 0.06, 11.0496:9.7114, nil, 18.0001:9.7114 )
    axlPathLine( path, 0.06, 11.0496:-69.6165 )
    axlPathLine( path, 0.06, 5.8506:-75.9502 )
    axlPathArcCenter( path, 0.06, 4.2796:-80.3514, nil, 11.2302:-80.3514 )
    axlPathLine( path, 0.06, 4.2796:-87.2193 )
    axlPathLine( path, 0.06, 4.1692:-87.4105 )
    axlPathLine( path, 0.06, 4.034:-87.6315 )
    axlPathArcCenter( path, 0.06, 3.8247:-87.989, nil, 16.0307:-94.8979 )
    axlPathArcCenter( path, 0.06, 3.5853:-88.4386, nil, 12.3748:-92.8305 )
    axlPathArcCenter( path, 0.06, 3.3913:-88.8581, nil, 10.7699:-92.0158 )
    axlPathArcCenter( path, 0.06, 3.1931:-89.3765, nil, 9.8695:-91.6312 )
    axlPathArcCenter( path, 0.06, 3.051:-89.8588, nil, 9.3294:-91.4479 )
    axlPathArcCenter( path, 0.06, 2.8676:-91.1383, nil, 8.9068:-91.3512 )
    axlPathLine( path, 0.06, 2.7964:-93.4942 )
    axlPathLine( path, 0.06, 2.2467:-94.4466 )
    axlPathArcCenter( path, 0.06, 1.4496:-97.4216, nil, 7.4:-97.4216 )
    axlPathLine( path, 0.06, 1.4496:-97.7114 )
    axlDBCreatePath( path, "ETCH/TOP", "GND")

    path = axlPathStart( (list 14.0799:18.8299))
    axlPathLine( path, 0.06, 14.0796:15.4507 )
    axlPathArcCenter( path, 0.06, 11.0496:9.7114, nil, 18.0001:9.7114 )
    axlPathLine( path, 0.06, 11.0496:-69.6165 )
    axlPathLine( path, 0.06, 5.8506:-75.9502 )
    axlPathArcCenter( path, 0.06, 4.2796:-80.3514, nil, 11.2302:-80.3514 )
    axlPathLine( path, 0.06, 4.2796:-87.2193 )
    axlPathLine( path, 0.06, 4.1692:-87.4105 )
    axlPathLine( path, 0.06, 4.034:-87.6315 )
    axlPathArcCenter( path, 0.06, 3.8247:-87.989, nil, 16.0307:-94.8979 )
    axlPathArcCenter( path, 0.06, 3.5853:-88.4386, nil, 12.3748:-92.8305 )
    axlPathArcCenter( path, 0.06, 3.3913:-88.8581, nil, 10.7699:-92.0158 )
    axlPathArcCenter( path, 0.06, 3.1931:-89.3765, nil, 9.8695:-91.6312 )
    axlPathArcCenter( path, 0.06, 3.051:-89.8588, nil, 9.3294:-91.4479 )
    axlPathArcCenter( path, 0.06, 2.8676:-91.1383, nil, 8.9068:-91.3512 )
    axlPathLine( path, 0.06, 2.7964:-93.4942 )
    axlPathLine( path, 0.06, 2.2467:-94.4466 )
    axlPathArcCenter( path, 0.06, 1.4496:-97.4216, nil, 7.4:-97.4216 )
    axlPathLine( path, 0.06, 1.4496:-97.7114 )
    axlDBCreatePath( path, "ETCH/BOTTOM", "GND")

    path = axlPathStart( (list 13.5916:18.8299))
    axlPathLine( path, 0.06, 13.5913:15.7029 )
    axlPathArcCenter( path, 0.06, 10.5613:9.7114, nil, 18.0001:9.7114 )
    axlPathLine( path, 0.06, 10.5613:-69.4418 )
    axlPathLine( path, 0.06, 5.4729:-75.6407 )
    axlPathArcCenter( path, 0.06, 3.7913:-80.3514, nil, 11.2302:-80.3514 )
    axlPathLine( path, 0.06, 3.7913:-87.0885 )
    axlPathLine( path, 0.06, 3.7494:-87.161 )
    axlPathLine( path, 0.06, 3.6169:-87.3776 )
    axlPathArcCenter( path, 0.06, 3.3997:-87.7485, nil, 16.0307:-94.8979 )
    axlPathArcCenter( path, 0.06, 3.1483:-88.2207, nil, 12.3748:-92.8305 )
    axlPathArcCenter( path, 0.06, 2.9424:-88.666, nil, 10.7699:-92.0158 )
    axlPathArcCenter( path, 0.06, 2.7305:-89.2203, nil, 9.8695:-91.6312 )
    axlPathArcCenter( path, 0.06, 2.5777:-89.7386, nil, 9.3294:-91.4479 )
    axlPathArcCenter( path, 0.06, 2.3795:-91.1223, nil, 8.9068:-91.3512 )
    axlPathLine( path, 0.06, 2.3121:-93.3566 )
    axlPathLine( path, 0.06, 1.8238:-94.2025 )
    axlPathArcCenter( path, 0.06, 0.9613:-97.4216, nil, 7.4:-97.4216 )
    axlPathLine( path, 0.06, 0.9613:-97.7114 )
    axlDBCreatePath( path, "ETCH/BOTTOM", "GND")

    path = axlPathStart( (list 13.5399:18.3548))
    axlPathLine( path, 0.06, 13.5396:15.729 )
    axlPathArcCenter( path, 0.06, 10.5096:9.7114, nil, 18.0001:9.7114 )
    axlPathLine( path, 0.06, 10.5096:-69.4233 )
    axlPathLine( path, 0.06, 5.4329:-75.6079 )
    axlPathArcCenter( path, 0.06, 3.7396:-80.3514, nil, 11.2302:-80.3514 )
    axlPathLine( path, 0.06, 3.7396:-87.0747 )
    axlPathLine( path, 0.06, 3.705:-87.1346 )
    axlPathLine( path, 0.06, 3.5728:-87.3507 )
    axlPathArcCenter( path, 0.06, 3.3547:-87.723, nil, 16.0307:-94.8979 )
    axlPathArcCenter( path, 0.06, 3.102:-88.1976, nil, 12.3748:-92.8305 )
    axlPathArcCenter( path, 0.06, 2.8948:-88.6456, nil, 10.7699:-92.0158 )
    axlPathArcCenter( path, 0.06, 2.6815:-89.2038, nil, 9.8695:-91.6312 )
    axlPathArcCenter( path, 0.06, 2.5276:-89.7259, nil, 9.3294:-91.4479 )
    axlPathArcCenter( path, 0.06, 2.3278:-91.1206, nil, 8.9068:-91.3512 )
    axlPathLine( path, 0.06, 2.2608:-93.342 )
    axlPathLine( path, 0.06, 1.779:-94.1766 )
    axlPathArcCenter( path, 0.06, 0.9096:-97.4216, nil, 7.4:-97.4216 )
    axlPathLine( path, 0.06, 0.9096:-97.7114 )
    axlDBCreatePath( path, "ETCH/TOP", "GND")

    ;; ===== net: USB_CONTACT_IN =====
    path = axlPathStart( (list 16.9999:18.8299))
    axlPathLine( path, 0.06, 16.9998:14.9248 )
    axlPathArcCenter( path, 0.06, 15.9998:13.2103, t, 15.03:14.9248 )
    axlPathArcCenter( path, 0.06, 13.9698:9.7114, nil, 18.0001:9.7114 )
    axlPathLine( path, 0.06, 13.9698:-69.9567 )
    axlPathArcCenter( path, 0.06, 13.9313:-70.3443, t, 12.0007:-69.9567 )
    axlPathArcCenter( path, 0.06, 13.891:-70.5085, t, 11.9986:-69.957 )
    axlPathArcCenter( path, 0.06, 13.5211:-71.2082, t, 12.0001:-69.9565 )
    axlPathLine( path, 0.06, 8.1095:-77.8009 )
    axlPathArcCenter( path, 0.06, 7.1998:-80.3514, nil, 11.2302:-80.3514 )
    axlPathLine( path, 0.06, 7.1998:-87.474 )
    axlPathArcCenter( path, 0.06, 6.931:-88.4674, t, 5.23:-87.474 )
    axlPathLine( path, 0.06, 6.6797:-88.9027 )
    axlPathLine( path, 0.06, 6.5286:-89.1496 )
    axlPathArcCenter( path, 0.06, 6.366:-89.4275, nil, 16.0307:-94.8979 )
    axlPathArcCenter( path, 0.06, 6.1985:-89.742, nil, 12.3748:-92.8305 )
    axlPathArcCenter( path, 0.06, 6.0759:-90.0072, nil, 10.7699:-92.0158 )
    axlPathArcCenter( path, 0.06, 5.9598:-90.3109, nil, 9.8695:-91.6312 )
    axlPathArcCenter( path, 0.06, 5.8813:-90.5777, nil, 9.3294:-91.4479 )
    axlPathArcCenter( path, 0.06, 5.7862:-91.235, nil, 8.9068:-91.3512 )
    axlPathLine( path, 0.06, 5.7003:-94.081 )
    axlPathArcCenter( path, 0.06, 5.6842:-94.1953, t, 5.1239:-94.0583 )
    axlPathArcCenter( path, 0.06, 5.6677:-94.2563, t, 4.8135:-93.9925 )
    axlPathArcCenter( path, 0.06, 5.6373:-94.3437, t, 4.4288:-93.8736 )
    axlPathArcCenter( path, 0.06, 5.5995:-94.4342, t, 3.7479:-93.608 )
    axlPathArcCenter( path, 0.06, 5.5315:-94.5761, t, 2.5637:-93.0665 )
    axlPathArcCenter( path, 0.06, 5.4585:-94.7154, t, -0.0826:-91.7202 )
    axlPathLine( path, 0.06, 5.3708:-94.8756 )
    axlPathLine( path, 0.06, 4.7758:-95.9065 )
    axlPathArcCenter( path, 0.06, 4.3698:-97.4216, nil, 7.4:-97.4216 )
    axlPathLine( path, 0.06, 4.3698:-97.7114 )
    axlDBCreatePath( path, "ETCH/BOTTOM", "USB_CONTACT_IN")

    ;; ===== net: AU_MICBIAS0 =====
    path = axlPathStart( (list 16.7599:18.3548))
    axlPathLine( path, 0.06, 16.7598:14.9248 )
    axlPathArcCenter( path, 0.06, 15.8812:13.4189, t, 15.03:14.9248 )
    axlPathArcCenter( path, 0.06, 13.7298:9.7114, nil, 18.0001:9.7114 )
    axlPathLine( path, 0.06, 13.7298:-69.9567 )
    axlPathArcCenter( path, 0.06, 13.696:-70.2971, t, 12.0007:-69.9567 )
    axlPathArcCenter( path, 0.06, 13.6606:-70.4413, t, 11.9986:-69.957 )
    axlPathArcCenter( path, 0.06, 13.3357:-71.0558, t, 12.0001:-69.9565 )
    axlPathLine( path, 0.06, 7.9238:-77.6488 )
    axlPathArcCenter( path, 0.06, 6.9598:-80.3514, nil, 11.2302:-80.3514 )
    axlPathLine( path, 0.06, 6.9598:-87.474 )
    axlPathArcCenter( path, 0.06, 6.7234:-88.3468, t, 5.23:-87.474 )
    axlPathLine( path, 0.06, 6.4734:-88.7801 )
    axlPathLine( path, 0.06, 6.3236:-89.0249 )
    axlPathArcCenter( path, 0.06, 6.1571:-89.3092, nil, 16.0307:-94.8979 )
    axlPathArcCenter( path, 0.06, 5.9837:-89.6349, nil, 12.3748:-92.8305 )
    axlPathArcCenter( path, 0.06, 5.8553:-89.9127, nil, 10.7699:-92.0158 )
    axlPathArcCenter( path, 0.06, 5.7324:-90.2341, nil, 9.8695:-91.6312 )
    axlPathArcCenter( path, 0.06, 5.6487:-90.5186, nil, 9.3294:-91.4479 )
    axlPathArcCenter( path, 0.06, 5.5463:-91.2269, nil, 8.9068:-91.3512 )
    axlPathLine( path, 0.06, 5.4604:-94.0725 )
    axlPathArcCenter( path, 0.06, 5.4508:-94.1395, t, 5.1239:-94.0583 )
    axlPathArcCenter( path, 0.06, 5.4384:-94.1854, t, 4.8135:-93.9925 )
    axlPathArcCenter( path, 0.06, 5.4136:-94.2567, t, 4.4288:-93.8736 )
    axlPathArcCenter( path, 0.06, 5.3805:-94.336, t, 3.7479:-93.608 )
    axlPathArcCenter( path, 0.06, 5.3176:-94.4673, t, 2.5637:-93.0665 )
    axlPathArcCenter( path, 0.06, 5.2476:-94.6007, t, -0.0826:-91.7202 )
    axlPathLine( path, 0.06, 5.1616:-94.758 )
    axlPathLine( path, 0.06, 4.5679:-95.7865 )
    axlPathArcCenter( path, 0.06, 4.1298:-97.4216, nil, 7.4:-97.4216 )
    axlPathLine( path, 0.06, 4.1298:-97.7114 )
    axlDBCreatePath( path, "ETCH/TOP", "AU_MICBIAS0")

    ;; ===== net: MAIN_MIC_P =====
    path = axlPathStart( (list 16.6399:18.3548))
    axlPathLine( path, 0.06, 16.6398:14.9248 )
    axlPathArcCenter( path, 0.06, 15.8219:13.5232, t, 15.03:14.9248 )
    axlPathArcCenter( path, 0.06, 13.6098:9.7114, nil, 18.0001:9.7114 )
    axlPathLine( path, 0.06, 13.6098:-69.9567 )
    axlPathArcCenter( path, 0.06, 13.5783:-70.2735, t, 12.0007:-69.9567 )
    axlPathArcCenter( path, 0.06, 13.5454:-70.4077, t, 11.9986:-69.957 )
    axlPathArcCenter( path, 0.06, 13.243:-70.9796, t, 12.0001:-69.9565 )
    axlPathLine( path, 0.06, 7.831:-77.5728 )
    axlPathArcCenter( path, 0.06, 6.8398:-80.3514, nil, 11.2302:-80.3514 )
    axlPathLine( path, 0.06, 6.8398:-87.474 )
    axlPathArcCenter( path, 0.06, 6.6197:-88.2866, t, 5.23:-87.474 )
    axlPathLine( path, 0.06, 6.3702:-88.7187 )
    axlPathLine( path, 0.06, 6.2211:-88.9625 )
    axlPathArcCenter( path, 0.06, 6.0527:-89.2501, nil, 16.0307:-94.8979 )
    axlPathArcCenter( path, 0.06, 5.8763:-89.5813, nil, 12.3748:-92.8305 )
    axlPathArcCenter( path, 0.06, 5.745:-89.8655, nil, 10.7699:-92.0158 )
    axlPathArcCenter( path, 0.06, 5.6188:-90.1957, nil, 9.8695:-91.6312 )
    axlPathArcCenter( path, 0.06, 5.5324:-90.4891, nil, 9.3294:-91.4479 )
    axlPathArcCenter( path, 0.06, 5.4264:-91.2229, nil, 8.9068:-91.3512 )
    axlPathLine( path, 0.06, 5.3405:-94.0681 )
    axlPathArcCenter( path, 0.06, 5.3341:-94.1115, t, 5.1239:-94.0583 )
    axlPathArcCenter( path, 0.06, 5.3237:-94.15, t, 4.8135:-93.9925 )
    axlPathArcCenter( path, 0.06, 5.3018:-94.2132, t, 4.4288:-93.8736 )
    axlPathArcCenter( path, 0.06, 5.271:-94.2869, t, 3.7479:-93.608 )
    axlPathArcCenter( path, 0.06, 5.2107:-94.4129, t, 2.5637:-93.0665 )
    axlPathArcCenter( path, 0.06, 5.1422:-94.5434, t, -0.0826:-91.7202 )
    axlPathLine( path, 0.06, 5.057:-94.6992 )
    axlPathLine( path, 0.06, 4.464:-95.7265 )
    axlPathArcCenter( path, 0.06, 4.0098:-97.4216, nil, 7.4:-97.4216 )
    axlPathLine( path, 0.06, 4.0098:-97.7114 )
    axlDBCreatePath( path, "ETCH/TOP", "MAIN_MIC_P")

    ;; ===== net: MAIN_MIC_M =====
    path = axlPathStart( (list 16.5199:18.3548))
    axlPathLine( path, 0.06, 16.5198:14.9248 )
    axlPathArcCenter( path, 0.06, 15.7626:13.6276, t, 15.03:14.9248 )
    axlPathArcCenter( path, 0.06, 13.4898:9.7114, nil, 18.0001:9.7114 )
    axlPathLine( path, 0.06, 13.4898:-69.9567 )
    axlPathArcCenter( path, 0.06, 13.4607:-70.2499, t, 12.0007:-69.9567 )
    axlPathArcCenter( path, 0.06, 13.4302:-70.3741, t, 11.9986:-69.957 )
    axlPathArcCenter( path, 0.06, 13.1503:-70.9034, t, 12.0001:-69.9565 )
    axlPathLine( path, 0.06, 7.7381:-77.4967 )
    axlPathArcCenter( path, 0.06, 6.7198:-80.3514, nil, 11.2302:-80.3514 )
    axlPathLine( path, 0.06, 6.7198:-87.474 )
    axlPathArcCenter( path, 0.06, 6.5159:-88.2263, t, 5.23:-87.474 )
    axlPathLine( path, 0.06, 6.267:-88.6574 )
    axlPathLine( path, 0.06, 6.1186:-88.9001 )
    axlPathArcCenter( path, 0.06, 5.9483:-89.191, nil, 16.0307:-94.8979 )
    axlPathArcCenter( path, 0.06, 5.7689:-89.5278, nil, 12.3748:-92.8305 )
    axlPathArcCenter( path, 0.06, 5.6346:-89.8183, nil, 10.7699:-92.0158 )
    axlPathArcCenter( path, 0.06, 5.5051:-90.1573, nil, 9.8695:-91.6312 )
    axlPathArcCenter( path, 0.06, 5.4161:-90.4595, nil, 9.3294:-91.4479 )
    axlPathArcCenter( path, 0.06, 5.3064:-91.2189, nil, 8.9068:-91.3512 )
    axlPathLine( path, 0.06, 5.2206:-94.0634 )
    axlPathArcCenter( path, 0.06, 5.2174:-94.0832, t, 5.1239:-94.0583 )
    axlPathArcCenter( path, 0.06, 5.2091:-94.1146, t, 4.8135:-93.9925 )
    axlPathArcCenter( path, 0.06, 5.1899:-94.1697, t, 4.4288:-93.8736 )
    axlPathArcCenter( path, 0.06, 5.1615:-94.2378, t, 3.7479:-93.608 )
    axlPathArcCenter( path, 0.06, 5.1037:-94.3585, t, 2.5637:-93.0665 )
    axlPathArcCenter( path, 0.06, 5.0368:-94.4861, t, -0.0826:-91.7202 )
    axlPathLine( path, 0.06, 4.9524:-94.6404 )
    axlPathLine( path, 0.06, 4.3601:-95.6665 )
    axlPathArcCenter( path, 0.06, 3.8898:-97.4216, nil, 7.4:-97.4216 )
    axlPathLine( path, 0.06, 3.8898:-97.7114 )
    axlDBCreatePath( path, "ETCH/TOP", "MAIN_MIC_M")

    ;; ===== net: BPI_D_BUS0 =====
    path = axlPathStart( (list 16.2799:18.8299))
    axlPathLine( path, 0.06, 16.2798:14.9248 )
    axlPathArcCenter( path, 0.06, 15.6441:13.8363, t, 15.03:14.9248 )
    axlPathArcCenter( path, 0.06, 13.2498:9.7114, nil, 18.0001:9.7114 )
    axlPathLine( path, 0.06, 13.2498:-69.9567 )
    axlPathArcCenter( path, 0.06, 13.2253:-70.2027, t, 12.0007:-69.9567 )
    axlPathArcCenter( path, 0.06, 13.1998:-70.3069, t, 11.9986:-69.957 )
    axlPathArcCenter( path, 0.06, 12.9649:-70.751, t, 12.0001:-69.9565 )
    axlPathLine( path, 0.06, 7.5525:-77.3446 )
    axlPathArcCenter( path, 0.06, 6.4798:-80.3514, nil, 11.2302:-80.3514 )
    axlPathLine( path, 0.06, 6.4798:-87.474 )
    axlPathArcCenter( path, 0.06, 6.3084:-88.1057, t, 5.23:-87.474 )
    axlPathLine( path, 0.06, 6.0607:-88.5348 )
    axlPathLine( path, 0.06, 5.9135:-88.7754 )
    axlPathArcCenter( path, 0.06, 5.7394:-89.0728, nil, 16.0307:-94.8979 )
    axlPathArcCenter( path, 0.06, 5.5542:-89.4207, nil, 12.3748:-92.8305 )
    axlPathArcCenter( path, 0.06, 5.414:-89.7238, nil, 10.7699:-92.0158 )
    axlPathArcCenter( path, 0.06, 5.2777:-90.0805, nil, 9.8695:-91.6312 )
    axlPathArcCenter( path, 0.06, 5.1835:-90.4004, nil, 9.3294:-91.4479 )
    axlPathArcCenter( path, 0.06, 5.0666:-91.2108, nil, 8.9068:-91.3512 )
    axlPathLine( path, 0.06, 4.9812:-94.0389 )
    axlPathArcCenter( path, 0.06, 4.9798:-94.0438, t, 4.8135:-93.9925 )
    axlPathArcCenter( path, 0.06, 4.9663:-94.0827, t, 4.4288:-93.8736 )
    axlPathArcCenter( path, 0.06, 4.9425:-94.1397, t, 3.7479:-93.608 )
    axlPathArcCenter( path, 0.06, 4.8898:-94.2497, t, 2.5637:-93.0665 )
    axlPathArcCenter( path, 0.06, 4.8259:-94.3715, t, -0.0826:-91.7202 )
    axlPathLine( path, 0.06, 4.7432:-94.5228 )
    axlPathLine( path, 0.06, 4.1522:-95.5465 )
    axlPathArcCenter( path, 0.06, 3.6498:-97.4216, nil, 7.4:-97.4216 )
    axlPathLine( path, 0.06, 3.6498:-97.7114 )
    axlDBCreatePath( path, "ETCH/BOTTOM", "BPI_D_BUS0")

    ;; ===== net: BPI_D_BUS4 =====
    path = axlPathStart( (list 16.1599:18.8299))
    axlPathLine( path, 0.06, 16.1598:14.9248 )
    axlPathArcCenter( path, 0.06, 15.5849:13.9406, t, 15.03:14.9248 )
    axlPathArcCenter( path, 0.06, 13.1298:9.7114, nil, 18.0001:9.7114 )
    axlPathLine( path, 0.06, 13.1298:-69.9567 )
    axlPathArcCenter( path, 0.06, 13.1077:-70.1791, t, 12.0007:-69.9567 )
    axlPathArcCenter( path, 0.06, 13.0846:-70.2733, t, 11.9986:-69.957 )
    axlPathArcCenter( path, 0.06, 12.8722:-70.6747, t, 12.0001:-69.9565 )
    axlPathLine( path, 0.06, 7.4596:-77.2686 )
    axlPathArcCenter( path, 0.06, 6.3598:-80.3514, nil, 11.2302:-80.3514 )
    axlPathLine( path, 0.06, 6.3598:-87.474 )
    axlPathArcCenter( path, 0.06, 6.2047:-88.0453, t, 5.23:-87.474 )
    axlPathLine( path, 0.06, 5.9575:-88.4735 )
    axlPathLine( path, 0.06, 5.811:-88.713 )
    axlPathArcCenter( path, 0.06, 5.635:-89.0137, nil, 16.0307:-94.8979 )
    axlPathArcCenter( path, 0.06, 5.4468:-89.3671, nil, 12.3748:-92.8305 )
    axlPathArcCenter( path, 0.06, 5.3037:-89.6766, nil, 10.7699:-92.0158 )
    axlPathArcCenter( path, 0.06, 5.164:-90.0421, nil, 9.8695:-91.6312 )
    axlPathArcCenter( path, 0.06, 5.0672:-90.3709, nil, 9.3294:-91.4479 )
    axlPathArcCenter( path, 0.06, 4.9466:-91.2068, nil, 8.9068:-91.3512 )
    axlPathLine( path, 0.06, 4.8617:-94.019 )
    axlPathArcCenter( path, 0.06, 4.8544:-94.0392, t, 4.4288:-93.8736 )
    axlPathArcCenter( path, 0.06, 4.833:-94.0906, t, 3.7479:-93.608 )
    axlPathArcCenter( path, 0.06, 4.7828:-94.1953, t, 2.5637:-93.0665 )
    axlPathArcCenter( path, 0.06, 4.7205:-94.3141, t, -0.0826:-91.7202 )
    axlPathLine( path, 0.06, 4.6385:-94.464 )
    axlPathLine( path, 0.06, 4.0483:-95.4865 )
    axlPathArcCenter( path, 0.06, 3.5298:-97.4216, nil, 7.4:-97.4216 )
    axlPathLine( path, 0.06, 3.5298:-97.7114 )
    axlDBCreatePath( path, "ETCH/BOTTOM", "BPI_D_BUS4")

    ;; ===== net: BB_USB_ADC2 =====
    path = axlPathStart( (list 16.0399:18.8299))
    axlPathLine( path, 0.06, 16.0397:14.9248 )
    axlPathArcCenter( path, 0.06, 15.5256:14.0451, t, 15.03:14.9248 )
    axlPathArcCenter( path, 0.06, 13.0097:9.7114, nil, 18.0001:9.7114 )
    axlPathLine( path, 0.06, 13.0097:-69.9567 )
    axlPathArcCenter( path, 0.06, 12.9899:-70.1555, t, 12.0007:-69.9567 )
    axlPathArcCenter( path, 0.06, 12.9693:-70.2396, t, 11.9986:-69.957 )
    axlPathArcCenter( path, 0.06, 12.7794:-70.5985, t, 12.0001:-69.9565 )
    axlPathLine( path, 0.06, 7.3667:-77.1925 )
    axlPathArcCenter( path, 0.06, 6.2397:-80.3514, nil, 11.2302:-80.3514 )
    axlPathLine( path, 0.06, 6.2397:-87.474 )
    axlPathArcCenter( path, 0.06, 6.1009:-87.9849, t, 5.23:-87.474 )
    axlPathLine( path, 0.06, 5.8543:-88.4121 )
    axlPathLine( path, 0.06, 5.7084:-88.6506 )
    axlPathArcCenter( path, 0.06, 5.5305:-88.9545, nil, 16.0307:-94.8979 )
    axlPathArcCenter( path, 0.06, 5.3393:-89.3135, nil, 12.3748:-92.8305 )
    axlPathArcCenter( path, 0.06, 5.1933:-89.6294, nil, 10.7699:-92.0158 )
    axlPathArcCenter( path, 0.06, 5.0502:-90.0037, nil, 9.8695:-91.6312 )
    axlPathArcCenter( path, 0.06, 4.9508:-90.3413, nil, 9.3294:-91.4479 )
    axlPathArcCenter( path, 0.06, 4.8266:-91.2028, nil, 8.9068:-91.3512 )
    axlPathLine( path, 0.06, 4.7423:-93.9963 )
    axlPathArcCenter( path, 0.06, 4.7234:-94.0415, t, 3.7479:-93.608 )
    axlPathArcCenter( path, 0.06, 4.6758:-94.1408, t, 2.5637:-93.0665 )
    axlPathArcCenter( path, 0.06, 4.615:-94.2568, t, -0.0826:-91.7202 )
    axlPathLine( path, 0.06, 4.5338:-94.4051 )
    axlPathLine( path, 0.06, 3.9443:-95.4265 )
    axlPathArcCenter( path, 0.06, 3.4097:-97.4216, nil, 7.4:-97.4216 )
    axlPathLine( path, 0.06, 3.4097:-97.7114 )
    axlDBCreatePath( path, "ETCH/BOTTOM", "BB_USB_ADC2")

    ;; ===== net: MIPI2_D_SCLK =====
    path = axlPathStart( (list 15.7999:18.3548))
    axlPathLine( path, 0.06, 15.7997:14.9248 )
    axlPathArcCenter( path, 0.06, 15.4073:14.2539, t, 15.03:14.9248 )
    axlPathArcCenter( path, 0.06, 12.7697:9.7114, nil, 18.0001:9.7114 )
    axlPathLine( path, 0.06, 12.7697:-69.9567 )
    axlPathArcCenter( path, 0.06, 12.7546:-70.1083, t, 12.0007:-69.9567 )
    axlPathArcCenter( path, 0.06, 12.7389:-70.1724, t, 11.9986:-69.957 )
    axlPathArcCenter( path, 0.06, 12.5941:-70.446, t, 12.0001:-69.9565 )
    axlPathLine( path, 0.06, 7.1811:-77.0404 )
    axlPathArcCenter( path, 0.06, 5.9997:-80.3514, nil, 11.2302:-80.3514 )
    axlPathLine( path, 0.06, 5.9997:-87.474 )
    axlPathArcCenter( path, 0.06, 5.8935:-87.8642, t, 5.23:-87.474 )
    axlPathLine( path, 0.06, 5.648:-88.2895 )
    axlPathLine( path, 0.06, 5.5034:-88.5258 )
    axlPathArcCenter( path, 0.06, 5.3216:-88.8363, nil, 16.0307:-94.8979 )
    axlPathArcCenter( path, 0.06, 5.1245:-89.2064, nil, 12.3748:-92.8305 )
    axlPathArcCenter( path, 0.06, 4.9726:-89.5349, nil, 10.7699:-92.0158 )
    axlPathArcCenter( path, 0.06, 4.8228:-89.9269, nil, 9.8695:-91.6312 )
    axlPathArcCenter( path, 0.06, 4.7182:-90.2822, nil, 9.3294:-91.4479 )
    axlPathArcCenter( path, 0.06, 4.5867:-91.1949, nil, 8.9068:-91.3512 )
    axlPathLine( path, 0.06, 4.5037:-93.9449 )
    axlPathArcCenter( path, 0.06, 4.4619:-94.032, t, 2.5637:-93.0665 )
    axlPathArcCenter( path, 0.06, 4.4041:-94.1422, t, -0.0826:-91.7202 )
    axlPathLine( path, 0.06, 4.3246:-94.2875 )
    axlPathLine( path, 0.06, 3.7364:-95.3065 )
    axlPathArcCenter( path, 0.06, 3.1697:-97.4216, nil, 7.4:-97.4216 )
    axlPathLine( path, 0.06, 3.1697:-97.7114 )
    axlDBCreatePath( path, "ETCH/TOP", "MIPI2_D_SCLK")

    ;; ===== net: MIPI2_D_SDATA =====
    path = axlPathStart( (list 15.6799:18.3548))
    axlPathLine( path, 0.06, 15.6797:14.9248 )
    axlPathArcCenter( path, 0.06, 15.3481:14.3583, t, 15.03:14.9248 )
    axlPathArcCenter( path, 0.06, 12.6497:9.7114, nil, 18.0001:9.7114 )
    axlPathLine( path, 0.06, 12.6497:-69.9567 )
    axlPathArcCenter( path, 0.06, 12.637:-70.0847, t, 12.0007:-69.9567 )
    axlPathArcCenter( path, 0.06, 12.6237:-70.1388, t, 11.9986:-69.957 )
    axlPathArcCenter( path, 0.06, 12.5014:-70.3698, t, 12.0001:-69.9565 )
    axlPathLine( path, 0.06, 7.0883:-76.9643 )
    axlPathArcCenter( path, 0.06, 5.8797:-80.3514, nil, 11.2302:-80.3514 )
    axlPathLine( path, 0.06, 5.8797:-87.474 )
    axlPathArcCenter( path, 0.06, 5.7898:-87.8037, t, 5.23:-87.474 )
    axlPathLine( path, 0.06, 5.5448:-88.2281 )
    axlPathLine( path, 0.06, 5.4009:-88.4634 )
    axlPathArcCenter( path, 0.06, 5.2172:-88.7772, nil, 16.0307:-94.8979 )
    axlPathArcCenter( path, 0.06, 5.0171:-89.1528, nil, 12.3748:-92.8305 )
    axlPathArcCenter( path, 0.06, 4.8623:-89.4877, nil, 10.7699:-92.0158 )
    axlPathArcCenter( path, 0.06, 4.7091:-89.8885, nil, 9.8695:-91.6312 )
    axlPathArcCenter( path, 0.06, 4.6018:-90.2527, nil, 9.3294:-91.4479 )
    axlPathArcCenter( path, 0.06, 4.4668:-91.1909, nil, 8.9068:-91.3512 )
    axlPathLine( path, 0.06, 4.3845:-93.9169 )
    axlPathArcCenter( path, 0.06, 4.3549:-93.9776, t, 2.5637:-93.0665 )
    axlPathArcCenter( path, 0.06, 4.2987:-94.0849, t, -0.0826:-91.7202 )
    axlPathLine( path, 0.06, 4.22:-94.2287 )
    axlPathLine( path, 0.06, 3.6325:-95.2465 )
    axlPathArcCenter( path, 0.06, 3.0497:-97.4216, nil, 7.4:-97.4216 )
    axlPathLine( path, 0.06, 3.0497:-97.7114 )
    axlDBCreatePath( path, "ETCH/TOP", "MIPI2_D_SDATA")

    ;; ===== net: BB_SUB_BATBOX_ADC3 =====
    path = axlPathStart( (list 15.4399:18.8299))
    axlPathLine( path, 0.06, 15.4397:14.9248 )
    axlPathArcCenter( path, 0.06, 15.23:14.5672, t, 15.03:14.9248 )
    axlPathArcCenter( path, 0.06, 12.4097:9.7114, nil, 18.0001:9.7114 )
    axlPathLine( path, 0.06, 12.4097:-69.9567 )
    axlPathArcCenter( path, 0.06, 12.4016:-70.0375, t, 12.0007:-69.9567 )
    axlPathArcCenter( path, 0.06, 12.3933:-70.0716, t, 11.9986:-69.957 )
    axlPathArcCenter( path, 0.06, 12.3161:-70.2173, t, 12.0001:-69.9565 )
    axlPathLine( path, 0.06, 6.9026:-76.8122 )
    axlPathArcCenter( path, 0.06, 5.6397:-80.3514, nil, 11.2302:-80.3514 )
    axlPathLine( path, 0.06, 5.6397:-87.474 )
    axlPathArcCenter( path, 0.06, 5.5825:-87.6827, t, 5.23:-87.474 )
    axlPathLine( path, 0.06, 5.3385:-88.1055 )
    axlPathLine( path, 0.06, 5.1959:-88.3387 )
    axlPathArcCenter( path, 0.06, 5.0083:-88.659, nil, 16.0307:-94.8979 )
    axlPathArcCenter( path, 0.06, 4.8024:-89.0457, nil, 12.3748:-92.8305 )
    axlPathArcCenter( path, 0.06, 4.6417:-89.3933, nil, 10.7699:-92.0158 )
    axlPathArcCenter( path, 0.06, 4.4817:-89.8117, nil, 9.8695:-91.6312 )
    axlPathArcCenter( path, 0.06, 4.3692:-90.1936, nil, 9.3294:-91.4479 )
    axlPathArcCenter( path, 0.06, 4.2269:-91.183, nil, 8.9068:-91.3512 )
    axlPathLine( path, 0.06, 4.1462:-93.8585 )
    axlPathArcCenter( path, 0.06, 4.141:-93.8688, t, 2.5637:-93.0665 )
    axlPathArcCenter( path, 0.06, 4.0878:-93.9703, t, -0.0826:-91.7202 )
    axlPathLine( path, 0.06, 4.0108:-94.1111 )
    axlPathLine( path, 0.06, 3.4246:-95.1265 )
    axlPathArcCenter( path, 0.06, 2.8097:-97.4216, nil, 7.4:-97.4216 )
    axlPathLine( path, 0.06, 2.8097:-97.7114 )
    axlDBCreatePath( path, "ETCH/BOTTOM", "BB_SUB_BATBOX_ADC3")

    ;; ===== net: BB_USB_ADC1 =====
    path = axlPathStart( (list 15.3199:18.8299))
    axlPathLine( path, 0.06, 15.3197:14.9248 )
    axlPathArcCenter( path, 0.06, 15.171:14.6717, t, 15.03:14.9248 )
    axlPathArcCenter( path, 0.06, 12.2897:9.7114, nil, 18.0001:9.7114 )
    axlPathLine( path, 0.06, 12.2897:-69.9567 )
    axlPathArcCenter( path, 0.06, 12.284:-70.0139, t, 12.0007:-69.9567 )
    axlPathArcCenter( path, 0.06, 12.2781:-70.038, t, 11.9986:-69.957 )
    axlPathArcCenter( path, 0.06, 12.2234:-70.141, t, 12.0001:-69.9565 )
    axlPathLine( path, 0.06, 6.8098:-76.7362 )
    axlPathArcCenter( path, 0.06, 5.5197:-80.3514, nil, 11.2302:-80.3514 )
    axlPathLine( path, 0.06, 5.5197:-87.474 )
    axlPathArcCenter( path, 0.06, 5.479:-87.6221, t, 5.23:-87.474 )
    axlPathLine( path, 0.06, 5.2353:-88.0442 )
    axlPathLine( path, 0.06, 5.0934:-88.2763 )
    axlPathArcCenter( path, 0.06, 4.9039:-88.5999, nil, 16.0307:-94.8979 )
    axlPathArcCenter( path, 0.06, 4.695:-88.9921, nil, 12.3748:-92.8305 )
    axlPathArcCenter( path, 0.06, 4.5313:-89.3461, nil, 10.7699:-92.0158 )
    axlPathArcCenter( path, 0.06, 4.368:-89.7733, nil, 9.8695:-91.6312 )
    axlPathArcCenter( path, 0.06, 4.2529:-90.1641, nil, 9.3294:-91.4479 )
    axlPathArcCenter( path, 0.06, 4.107:-91.179, nil, 8.9068:-91.3512 )
    axlPathLine( path, 0.06, 4.027:-93.8281 )
    axlPathArcCenter( path, 0.06, 3.9824:-93.913, t, -0.0826:-91.7202 )
    axlPathLine( path, 0.06, 3.9062:-94.0523 )
    axlPathLine( path, 0.06, 3.3207:-95.0665 )
    axlPathArcCenter( path, 0.06, 2.6897:-97.4216, nil, 7.4:-97.4216 )
    axlPathLine( path, 0.06, 2.6897:-97.7114 )
    axlDBCreatePath( path, "ETCH/BOTTOM", "BB_USB_ADC1")

    ;; ===== net: OLED_NTC =====
    path = axlPathStart( (list 15.1999:18.8299))
    axlPathLine( path, 0.06, 15.1997:14.9248 )
    axlPathArcCenter( path, 0.06, 15.1121:14.7763, t, 15.03:14.9248 )
    axlPathArcCenter( path, 0.06, 12.1697:9.7114, nil, 18.0001:9.7114 )
    axlPathLine( path, 0.06, 12.1697:-69.9567 )
    axlPathArcCenter( path, 0.06, 12.1663:-69.9903, t, 12.0007:-69.9567 )
    axlPathArcCenter( path, 0.06, 12.1629:-70.0044, t, 11.9986:-69.957 )
    axlPathArcCenter( path, 0.06, 12.1308:-70.0647, t, 12.0001:-69.9565 )
    axlPathLine( path, 0.06, 6.717:-76.6601 )
    axlPathArcCenter( path, 0.06, 5.3997:-80.3514, nil, 11.2302:-80.3514 )
    axlPathLine( path, 0.06, 5.3997:-87.474 )
    axlPathArcCenter( path, 0.06, 5.3755:-87.5614, t, 5.23:-87.474 )
    axlPathLine( path, 0.06, 5.1322:-87.9829 )
    axlPathLine( path, 0.06, 4.9908:-88.2139 )
    axlPathArcCenter( path, 0.06, 4.7994:-88.5407, nil, 16.0307:-94.8979 )
    axlPathArcCenter( path, 0.06, 4.5876:-88.9386, nil, 12.3748:-92.8305 )
    axlPathArcCenter( path, 0.06, 4.421:-89.2988, nil, 10.7699:-92.0158 )
    axlPathArcCenter( path, 0.06, 4.2544:-89.7349, nil, 9.8695:-91.6312 )
    axlPathArcCenter( path, 0.06, 4.1366:-90.1345, nil, 9.3294:-91.4479 )
    axlPathArcCenter( path, 0.06, 3.9871:-91.175, nil, 8.9068:-91.3512 )
    axlPathLine( path, 0.06, 3.9079:-93.7973 )
    axlPathArcCenter( path, 0.06, 3.8769:-93.8557, t, -0.0826:-91.7202 )
    axlPathLine( path, 0.06, 3.8015:-93.9935 )
    axlPathLine( path, 0.06, 3.2168:-95.0066 )
    axlPathArcCenter( path, 0.06, 2.5697:-97.4216, nil, 7.4:-97.4216 )
    axlPathLine( path, 0.06, 2.5697:-97.7114 )
    axlDBCreatePath( path, "ETCH/BOTTOM", "OLED_NTC")

    ;; ===== net: ANT_ID0 =====
    path = axlPathStart( (list 15.0799:18.8299))
    axlPathLine( path, 0.06, 15.0796:14.9248 )
    axlPathArcCenter( path, 0.06, 15.0535:14.8811, t, 15.03:14.9248 )
    axlPathArcCenter( path, 0.06, 12.0496:9.7114, nil, 18.0001:9.7114 )
    axlPathLine( path, 0.06, 12.0496:-69.9567 )
    axlPathArcCenter( path, 0.06, 12.0486:-69.9667, t, 12.0007:-69.9567 )
    axlPathArcCenter( path, 0.06, 12.0476:-69.9708, t, 11.9986:-69.957 )
    axlPathArcCenter( path, 0.06, 12.0382:-69.9883, t, 12.0001:-69.9565 )
    axlPathLine( path, 0.06, 6.6241:-76.584 )
    axlPathArcCenter( path, 0.06, 5.2796:-80.3514, nil, 11.2302:-80.3514 )
    axlPathLine( path, 0.06, 5.2796:-87.474 )
    axlPathArcCenter( path, 0.06, 5.2721:-87.5001, t, 5.23:-87.474 )
    axlPathLine( path, 0.06, 5.0289:-87.9215 )
    axlPathLine( path, 0.06, 4.8882:-88.1514 )
    axlPathArcCenter( path, 0.06, 4.6949:-88.4816, nil, 16.0307:-94.8979 )
    axlPathArcCenter( path, 0.06, 4.4801:-88.885, nil, 12.3748:-92.8305 )
    axlPathArcCenter( path, 0.06, 4.3106:-89.2516, nil, 10.7699:-92.0158 )
    axlPathArcCenter( path, 0.06, 4.1406:-89.6965, nil, 9.8695:-91.6312 )
    axlPathArcCenter( path, 0.06, 4.0202:-90.105, nil, 9.3294:-91.4479 )
    axlPathArcCenter( path, 0.06, 3.867:-91.1711, nil, 8.9068:-91.3512 )
    axlPathLine( path, 0.06, 3.7887:-93.766 )
    axlPathArcCenter( path, 0.06, 3.7714:-93.7984, t, -0.0826:-91.7202 )
    axlPathLine( path, 0.06, 3.6968:-93.9346 )
    axlPathLine( path, 0.06, 3.1128:-94.9465 )
    axlPathArcCenter( path, 0.06, 2.4496:-97.4216, nil, 7.4:-97.4216 )
    axlPathLine( path, 0.06, 2.4496:-97.7114 )
    axlDBCreatePath( path, "ETCH/BOTTOM", "ANT_ID0")

    ;; ===== net: USB_DP_CON =====
    path = axlPathStart( (list 14.7874:18.3548))
    axlPathLine( path, 0.085, 14.7872:15.0641 )
    axlPathArcCenter( path, 0.085, 11.7572:9.7114, nil, 18.0001:9.7114 )
    axlPathLine( path, 0.085, 11.7572:-69.8697 )
    axlPathLine( path, 0.085, 6.3979:-76.3987 )
    axlPathArcCenter( path, 0.085, 4.9872:-80.3514, nil, 11.2302:-80.3514 )
    axlPathLine( path, 0.085, 4.9872:-87.4089 )
    axlPathLine( path, 0.085, 4.7775:-87.7721 )
    axlPathLine( path, 0.085, 4.6385:-87.9994 )
    axlPathArcCenter( path, 0.085, 4.4405:-88.3375, nil, 16.0307:-94.8979 )
    axlPathArcCenter( path, 0.085, 4.2185:-88.7545, nil, 12.3748:-92.8305 )
    axlPathArcCenter( path, 0.085, 4.0418:-89.1365, nil, 10.7699:-92.0158 )
    axlPathArcCenter( path, 0.085, 3.8635:-89.6029, nil, 9.8695:-91.6312 )
    axlPathArcCenter( path, 0.085, 3.7368:-90.033, nil, 9.3294:-91.4479 )
    axlPathArcCenter( path, 0.085, 3.5748:-91.1614, nil, 8.9068:-91.3512 )
    axlPathLine( path, 0.085, 3.4985:-93.688 )
    axlPathLine( path, 0.085, 3.4419:-93.7914 )
    axlPathLine( path, 0.085, 2.8595:-94.8003 )
    axlPathArcCenter( path, 0.085, 2.1572:-97.4216, nil, 7.4:-97.4216 )
    axlPathLine( path, 0.085, 2.1572:-97.7114 )
    axlDBCreatePath( path, "ETCH/TOP", "USB_DP_CON")

    ;; ===== net: USB_DM_CON =====
    path = axlPathStart( (list 14.6024:18.3548))
    axlPathLine( path, 0.085, 14.6021:15.1678 )
    axlPathArcCenter( path, 0.085, 11.5721:9.7114, nil, 18.0001:9.7114 )
    axlPathLine( path, 0.085, 11.5721:-69.8035 )
    axlPathLine( path, 0.085, 6.2547:-76.2814 )
    axlPathArcCenter( path, 0.085, 4.8021:-80.3514, nil, 11.2302:-80.3514 )
    axlPathLine( path, 0.085, 4.8021:-87.3593 )
    axlPathLine( path, 0.085, 4.6184:-87.6775 )
    axlPathLine( path, 0.085, 4.4804:-87.9032 )
    axlPathArcCenter( path, 0.085, 4.2794:-88.2464, nil, 16.0307:-94.8979 )
    axlPathArcCenter( path, 0.085, 4.0528:-88.6719, nil, 12.3748:-92.8305 )
    axlPathArcCenter( path, 0.085, 3.8716:-89.0637, nil, 10.7699:-92.0158 )
    axlPathArcCenter( path, 0.085, 3.6882:-89.5437, nil, 9.8695:-91.6312 )
    axlPathArcCenter( path, 0.085, 3.5574:-89.9874, nil, 9.3294:-91.4479 )
    axlPathArcCenter( path, 0.085, 3.3898:-91.1554, nil, 8.9068:-91.3512 )
    axlPathLine( path, 0.085, 3.3148:-93.638 )
    axlPathLine( path, 0.085, 3.2806:-93.7007 )
    axlPathLine( path, 0.085, 2.6992:-94.7078 )
    axlPathArcCenter( path, 0.085, 1.9721:-97.4216, nil, 7.4:-97.4216 )
    axlPathLine( path, 0.085, 1.9721:-97.7114 )
    axlDBCreatePath( path, "ETCH/TOP", "USB_DM_CON")

    ;; ===== net: VIBR_PMU =====
    path = axlPathStart( (list 14.2549:18.8299))
    axlPathLine( path, 0.17, 14.2547:15.3575 )
    axlPathArcCenter( path, 0.17, 11.2247:9.7114, nil, 18.0001:9.7114 )
    axlPathLine( path, 0.17, 11.2247:-69.6792 )
    axlPathLine( path, 0.17, 5.986:-76.0612 )
    axlPathArcCenter( path, 0.17, 4.4547:-80.3514, nil, 11.2302:-80.3514 )
    axlPathLine( path, 0.17, 4.4547:-87.2662 )
    axlPathLine( path, 0.17, 4.3198:-87.5 )
    axlPathLine( path, 0.17, 4.1836:-87.7226 )
    axlPathArcCenter( path, 0.17, 3.977:-88.0752, nil, 16.0307:-94.8979 )
    axlPathArcCenter( path, 0.17, 3.742:-88.5168, nil, 12.3748:-92.8305 )
    axlPathArcCenter( path, 0.17, 3.5523:-88.927, nil, 10.7699:-92.0158 )
    axlPathArcCenter( path, 0.17, 3.359:-89.4326, nil, 9.8695:-91.6312 )
    axlPathArcCenter( path, 0.17, 3.2207:-89.9019, nil, 9.3294:-91.4479 )
    axlPathArcCenter( path, 0.17, 3.0426:-91.144, nil, 8.9068:-91.3512 )
    axlPathLine( path, 0.17, 2.9701:-93.5436 )
    axlPathLine( path, 0.17, 2.3983:-94.5341 )
    axlPathArcCenter( path, 0.17, 1.6247:-97.4216, nil, 7.4:-97.4216 )
    axlPathLine( path, 0.17, 1.6247:-97.7114 )
    axlDBCreatePath( path, "ETCH/BOTTOM", "VIBR_PMU")

    ;; ===== net: USB_CC1 =====
    path = axlPathStart( (list 13.9149:18.3548))
    axlPathLine( path, 0.15, 13.9147:15.5371 )
    axlPathArcCenter( path, 0.15, 10.8847:9.7114, nil, 18.0001:9.7114 )
    axlPathLine( path, 0.15, 10.8847:-69.5575 )
    axlPathLine( path, 0.15, 5.7231:-75.8457 )
    axlPathArcCenter( path, 0.15, 4.1147:-80.3514, nil, 11.2302:-80.3514 )
    axlPathLine( path, 0.15, 4.1147:-87.1751 )
    axlPathLine( path, 0.15, 4.0275:-87.3263 )
    axlPathLine( path, 0.15, 3.8932:-87.5458 )
    axlPathArcCenter( path, 0.15, 3.6812:-87.9078, nil, 16.0307:-94.8979 )
    axlPathArcCenter( path, 0.15, 3.4377:-88.365, nil, 12.3748:-92.8305 )
    axlPathArcCenter( path, 0.15, 3.2397:-88.7932, nil, 10.7699:-92.0158 )
    axlPathArcCenter( path, 0.15, 3.0369:-89.3238, nil, 9.8695:-91.6312 )
    axlPathArcCenter( path, 0.15, 2.8912:-89.8182, nil, 9.3294:-91.4479 )
    axlPathArcCenter( path, 0.15, 2.7027:-91.1329, nil, 8.9068:-91.3512 )
    axlPathLine( path, 0.15, 2.6329:-93.4477 )
    axlPathLine( path, 0.15, 2.1039:-94.3642 )
    axlPathArcCenter( path, 0.15, 1.2847:-97.4216, nil, 7.4:-97.4216 )
    axlPathLine( path, 0.15, 1.2847:-97.7114 )
    axlDBCreatePath( path, "ETCH/TOP", "USB_CC1")

    ;; ===== net: USB_CC2 =====
    path = axlPathStart( (list 13.7049:18.3548))
    axlPathLine( path, 0.15, 13.7046:15.6453 )
    axlPathArcCenter( path, 0.15, 10.6746:9.7114, nil, 18.0001:9.7114 )
    axlPathLine( path, 0.15, 10.6746:-69.4823 )
    axlPathLine( path, 0.15, 5.5606:-75.7125 )
    axlPathArcCenter( path, 0.15, 3.9046:-80.3514, nil, 11.2302:-80.3514 )
    axlPathLine( path, 0.15, 3.9046:-87.1189 )
    axlPathLine( path, 0.15, 3.8468:-87.2189 )
    axlPathLine( path, 0.15, 3.7137:-87.4365 )
    axlPathArcCenter( path, 0.15, 3.4983:-87.8043, nil, 16.0307:-94.8979 )
    axlPathArcCenter( path, 0.15, 3.2497:-88.2713, nil, 12.3748:-92.8305 )
    axlPathArcCenter( path, 0.15, 3.0465:-88.7106, nil, 10.7699:-92.0158 )
    axlPathArcCenter( path, 0.15, 2.8378:-89.2565, nil, 9.8695:-91.6312 )
    axlPathArcCenter( path, 0.15, 2.6875:-89.7665, nil, 9.3294:-91.4479 )
    axlPathArcCenter( path, 0.15, 2.4928:-91.126, nil, 8.9068:-91.3512 )
    axlPathLine( path, 0.15, 2.4245:-93.3885 )
    axlPathLine( path, 0.15, 1.9219:-94.2591 )
    axlPathArcCenter( path, 0.15, 1.0746:-97.4216, nil, 7.4:-97.4216 )
    axlPathLine( path, 0.15, 1.0746:-97.7114 )
    axlDBCreatePath( path, "ETCH/TOP", "USB_CC2")

    (axlUIConfirm "Nets import completed. \n")
    t
  )
)
