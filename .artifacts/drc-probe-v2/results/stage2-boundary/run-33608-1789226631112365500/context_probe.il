(putd '__v2PureClass nil)
(defun __v2PureClass (x)
  (if x then (list nil 'name x->name 'objType x->objType 'properties (axlDBGetProperties x) 'netclass1 x->netclass1 'netclass2 x->netclass2 'region x->region 'spacing x->spacing 'prop x->prop) else nil))
(putd '__v2ClassTableList nil)
(defun __v2ClassTableList (xs result)
  (if xs then (__v2ClassTableList (cdr xs) (cons (__v2PureClass (car xs)) result)) else (reverse result)))
(putd '__v2DrcContextPure nil)
(defun __v2DrcContextPure (nameA nameB)
  (let ((na (axlDBFindByName 'net nameA)) (nb (axlDBFindByName 'net nameB)) ca cb ha hb)
    (setq ca (if na then (axlNetClassGet na 'spacing nil) else nil))
    (setq cb (if nb then (axlNetClassGet nb 'spacing nil) else nil))
    (setq ha (if na then (axlNetClassGet na 'spacing t) else nil))
    (setq hb (if nb then (axlNetClassGet nb 'spacing t) else nil))
    (list nil
      'netA (list nil 'name nameA 'found (if na then t else nil) 'properties (if na then (axlDBGetProperties na) else nil) 'directClass (__v2PureClass ca) 'hierClass (__v2PureClass ha))
      'netB (list nil 'name nameB 'found (if nb then t else nil) 'properties (if nb then (axlDBGetProperties nb) else nil) 'directClass (__v2PureClass cb) 'hierClass (__v2PureClass hb))
      'classTables (list nil
        'netclass (__v2ClassTableList (axlCnsClassTableFind 'netclass) nil)
        'classClass (__v2ClassTableList (axlCnsClassTableFind 'classClass) nil)
        'classRegion (__v2ClassTableList (axlCnsClassTableFind 'classRegion) nil)
        'classClassRegion (__v2ClassTableList (axlCnsClassTableFind 'classClassRegion) nil)))))
