(defun __abpBenchVersion ()
  (axlVersion 'fullVersion))
