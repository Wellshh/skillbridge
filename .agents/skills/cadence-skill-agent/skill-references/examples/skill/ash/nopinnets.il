;;;;;;;;;;;;;;;;;;;;;;;;;;;;;;;;;;;;;;;;;;;;;;;;;;;;;;;;;;;;;;;;;;;;;;;;;;;;;
 ; Author --
 ;      Cadence Design Systems
 ;
 ; Function --
 ;
 ; Copyright, 2000, Cadence Design Systems, Inc.
 ; No part of this file may be reproduced, stored in a retrieval system,
 ; or transmitted in any form or by any means --- electronic, mechanical,
 ; photocopying, recording, or otherwise --- without prior written permission
 ; of Cadence Design Systems, Inc.
 ;
 ; WARRANTY:
 ; NONE. NONE. NONE.
 ; Use all material in this code at your own risk.  Cadence Design Systems
 ; makes no claims about any material in this archive.  These examples may
 ; not function or may only function in specific instances. We'd like to hear
 ; what you think of our approach to this, and how we can improve it.
 ;
 ; RESTRICTIONS:
 ; All software contained within this archive is in the public domain or
 ; the author has given us permission for redistribution.  Some packages
 ; have explicit copyrights and notices concerning their redistribution.
 ; Please carefully read all documentation with any package on this tape.
 ;;;;;;;;;;;;;;;;;;;;;;;;;;;;;;;;;;;;;;;;;;;;;;;;;;;;;;;;;;;;;;;;;;;;;;;;;;;;;

; TO USE:
;	load file (or place in ~/pcbenv/allego.ilinit file)
;	on allegro command line type: nopinnets
;

procedure( ashNetsWithNoPins()
    (let (nets port file msg done )
	file = "nopinnets.log"
	msg = "Nets with no pins"
	nets = axlDBGetDesign()->nets
	port = axlDMOpenLog(file)
	fprintf(port "%s:\n" msg)
	done = 0
	foreach(item nets
	    unless(item->branches
		fprintf(port "\t%s\n" item->name)
		++done)
	)
	if(done then
	    fprintf(port "\nTotal nets with no pins: %d\n" done)
	else
	    fprintf(port "\n No nets with no pins\n")
	)
	axlDMClose(port)
	axlUIViewFileCreate(file msg nil '(30 25) '(CENTER))
))

axlCmdRegister("nopinnets" 'ashNetsWithNoPins ?cmdType "general")
