;;;;;;;;;;;;;;;;;;;;;;;;;;;;;;;;;;;;;;;;;;;;;;;;;;;;;;;;;;;;;;;;;;;;;;;;;;;;;
 ; file.cc --
 ;
 ; Author --
 ;	Cadence Design Systems
 ;
 ; Function --
 ;
 ; Copyright, 1993, Cadence Design Systems, Inc.
 ; No part of this file may be reproduced, stored in a retrieval system,
 ; or transmitted in any form or by any means --- electronic, mechanical,
 ; photocopying, recording, or otherwise --- without prior written permission
 ; of Cadence Design Systems, Inc.
 ;
 ; WARRANTY:
 ; NONE. NONE. NONE.
 ; Use all material in this code at your own risk.  Cadence Design Systems
 ; makes no claims about any material in this archive.  These examples may
 ; not function or may only function in specific instances. We'd like to hear
 ; what you think of our approach to this, and how we can improve it.
 ;
 ; RESTRICTIONS:
 ; All software contained within this archive is in the public domain or
 ; the author has given us permission for redistribution.  Some packages
 ; have explicit copyrights and notices concerning their redistribution.
 ; Please carefully read all documentation with any package on this tape.
 ;;;;;;;;;;;;;;;;;;;;;;;;;;;;;;;;;;;;;;;;;;;;;;;;;;;;;;;;;;;;;;;;;;;;;;;;;;;;;

;
; allow user to single object and return it
;	p = ashOne()

(defun ashOne (@optional types)
    "Select Allegro objects and call user provided function"
    (let (oldPopup)
	axlClearSelSet()
	(setq oldPopup
	      (axlUIPopupSet (axlUIPopupDefine nil
				'(("Cancel" axlCancelEnterFun)))))
	unless( types
	     types = "NOALLTYPES"
	)
	(axlSetFindFilter ?enabled '("NOALL" "ALLTYPES" "AUTOFORM" "NAMEFORM")
			  ?onButtons types)
	(axlSelect)
	    (axlUIPopupSet oldPopup)
	car(axlGetSelSet())
	)
)

(defun ashShow () (ashSelect 'axlShowObject))
(defun _ashSelectDebug () (ashSelect '_axlDebugObjList))
