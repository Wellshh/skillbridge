;;;;;;;;;;;;;;;;;;;;;;;;;;;;;;;;;;;;;;;;;;;;;;;;;;;;;;;;;;;;;;;;;;;;;;;;;;;;;
 ; file.cc --
 ;
 ; Author --
 ;	Cadence Design Systems
 ;
 ; Function --
 ;
 ; Copyright, 1993, Cadence Design Systems, Inc.
 ; No part of this file may be reproduced, stored in a retrieval system,
 ; or transmitted in any form or by any means --- electronic, mechanical,
 ; photocopying, recording, or otherwise --- without prior written permission
 ; of Cadence Design Systems, Inc.
 ;
 ; WARRANTY:
 ; NONE. NONE. NONE.
 ; Use all material in this code at your own risk.  Cadence Design Systems
 ; makes no claims about any material in this archive.  These examples may
 ; not function or may only function in specific instances. We'd like to hear
 ; what you think of our approach to this, and how we can improve it.
 ;
 ; RESTRICTIONS:
 ; All software contained within this archive is in the public domain or
 ; the author has given us permission for redistribution.  Some packages
 ; have explicit copyrights and notices concerning their redistribution.
 ; Please carefully read all documentation with any package on this tape.
 ;;;;;;;;;;;;;;;;;;;;;;;;;;;;;;;;;;;;;;;;;;;;;;;;;;;;;;;;;;;;;;;;;;;;;;;;;;;;;

;; test_design  - test  Design Parameter access
;find all Design Attrs
 ;;    print out all attributes of Design Parameter type

  (defun test_design (p)
    (pprint (setq dsn (axlGetParam "paramDesign")) p)
    (fprintf p "\n")
    (pprint dsn->?? p)
;    (pprint (dsn->accuracy=2) p)
    (fprintf p "\n")
    (fprintf p "Setting accuracy to: ")
    (pprint (putprop dsn 2 'accuracy) p)
    (fprintf p "\n")
    (fprintf p "Found accuracy to be: ")
    (pprint dsn->accuracy  p)
;    (pprint (putprop dsn 35.0 'width) p)
    (fprintf p "\n")
    (fprintf p "Setting width to: ")
   (pprint (dsn->width=10000) p)
    (fprintf p "\n")
    (fprintf p "Found width to be: ")
   (pprint dsn->width p)
    (fprintf p "\n")
    (fprintf p "Setting units to: ")
   (pprint (dsn->units="microns") p)
    (fprintf p "\n")
    (fprintf p "Found units to be: ")
    (pprint dsn->units p)
    (fprintf p "\n")
    (fprintf p "Setting height to: ")
   (pprint (dsn->height=1500) p)
    (fprintf p "\n")
    (fprintf p "Found height to be: ")
   (pprint dsn->height p)
    (fprintf p "\n")
;;
;; Set param will fail as x coord of origin exceeds limits
;;
    (fprintf p "Setting origin to: ")
;   (pprint (dsn->xy=(180000000 10.0) p) (max 1 and 6 zeroes)
    (pprint (putprop dsn '(1000001.0  10.0) 'xy) p)
    (fprintf p "\n")
    (fprintf p "Found origin to be: ")
   (pprint dsn->xy p)
    (fprintf p "\n")
    (fprintf p "Setting objtype to: ")
   (pprint (dsn->objtype="Design") p)
    (fprintf p "\n")
    (fprintf p "Expecting nil, found objtype to be: ")
   (pprint dsn->objtype p)
    (fprintf p "\n")
    (pprint dsn->?? p)
    (fprintf p "\n")
    (fprintf p "\n")
    (fprintf p "Setting design object,expecting nil, found to be: ")
   (pprint (axlSetParam dsn) p)
    (fprintf p "\n")
    (fprintf p "Returned nil as X-coord of origin exceeds bounds")
    (fprintf p "\n")
    (fprintf p "Retrieving design object, found to be: ")
    (pprint (setq dsn (axlGetParam "paramDesign")) p)
    (fprintf p "\n")
    (pprint dsn->?? p)
    (fprintf p "\n")
   ) ; defun test_design

  (defun test_design1 (p)
    (pprint (setq dsn (axlGetParam "paramDesign")) p)
    (fprintf p "\n")
    (pprint dsn->?? p)
    (fprintf p "\n")
;;
;; Set param will fail as accuracy is illegal
;;
    (fprintf p "Setting accuracy to: ")
    (pprint (putprop dsn 5 'accuracy) p)
    (fprintf p "\n")
    (fprintf p "Found accuracy to be: ")
    (pprint dsn->accuracy  p)
    (fprintf p "\n")
    (fprintf p "Setting units to: ")
    (pprint (dsn->units="mils") p)
    (fprintf p "\n")
    (fprintf p "Found units to be: ")
    (pprint dsn->units p)
    (fprintf p "\n")
    (pprint dsn->?? p)
    (fprintf p "\n")
    (fprintf p "\n")
    (fprintf p "Setting design object,expecting nil, found to be: ")
   (pprint (axlSetParam dsn) p)
    (fprintf p "\n")
    (fprintf p "Returned nil as accuracy of 5 is not valid")
    (fprintf p "\n")
    (fprintf p "Retrieving design object, found to be: ")
    (pprint (setq dsn (axlGetParam "paramDesign")) p)
    (fprintf p "\n")
    (pprint dsn->?? p)
    (fprintf p "\n")
   ) ; defun test_design1

  (defun test_design2 (p)
    (pprint (setq dsn (axlGetParam "paramDesign")) p)
    (fprintf p "\n")
    (pprint dsn->?? p)
    (fprintf p "\n")
;;
;; Set Param will fail as width and height are not compatible
;;
    (fprintf p "Setting width to: ")
   (pprint (dsn->width=2.0) p)
    (fprintf p "\n")
    (fprintf p "Found width to be: ")
   (pprint dsn->width p)
    (fprintf p "\n")
    (fprintf p "Setting height to: ")
   (pprint (dsn->height=15000) p)
    (fprintf p "\n")
    (fprintf p "Found height to be: ")
   (pprint dsn->height p)
    (fprintf p "\n")
    (pprint dsn->?? p)
    (fprintf p "\n")
    (fprintf p "\n")
    (fprintf p "Setting design object,expecting nil, found to be: ")
   (pprint (axlSetParam dsn) p)
    (fprintf p "\n")
    (fprintf p "Returned nil as width and height are not compatible")
    (fprintf p "\n")
    (fprintf p "Retrieving design object, found to be: ")
    (pprint (setq dsn (axlGetParam "paramDesign")) p)
    (fprintf p "\n")
    (pprint dsn->?? p)
    (fprintf p "\n")
   ) ; defun test_design2

  (defun test_design3 (p)
    (pprint (setq dsn (axlGetParam "paramDesign")) p)
    (fprintf p "\n")
    (pprint dsn->?? p)
    (fprintf p "\n")
;    (pprint (putprop dsn 35.0 'width) p)
    (fprintf p "Setting width to: ")
   (pprint (dsn->width=15000) p)
    (fprintf p "\n")
    (fprintf p "Found width to be: ")
   (pprint dsn->width p)
    (fprintf p "\n")
    (fprintf p "Setting height to: ")
   (pprint (dsn->height=-1.0) p)
    (fprintf p "\n")
    (fprintf p "Found height to be: ")
   (pprint dsn->height p)
    (fprintf p "\n")
    (pprint dsn->?? p)
    (fprintf p "\n")
    (fprintf p "\n")
    (fprintf p "Setting design object,expecting nil, found to be: ")
   (pprint (axlSetParam dsn) p)
    (fprintf p "\n")
    (fprintf p "Returned nil as height is negative")
    (fprintf p "\n")
    (fprintf p "Retrieving design object, found to be: ")
    (pprint (setq dsn (axlGetParam "paramDesign")) p)
    (fprintf p "\n")
    (pprint dsn->?? p)
    (fprintf p "\n")
   ) ; defun test_design3

  (defun test_design4 (p)
    (pprint (setq dsn (axlGetParam "paramDesign")) p)
    (fprintf p "\n")
    (pprint dsn->?? p)
    (fprintf p "\n")
;    (pprint (putprop dsn 35.0 'width) p)
    (fprintf p "Setting width to: ")
   (pprint (dsn->width=0.0) p)
    (fprintf p "\n")
    (fprintf p "Found width to be: ")
   (pprint dsn->width p)
    (fprintf p "\n")
    (fprintf p "Setting height to: ")
   (pprint (dsn->height=0.0) p)
    (fprintf p "\n")
    (fprintf p "Found height to be: ")
   (pprint dsn->height p)
    (fprintf p "\n")
    (pprint dsn->?? p)
    (fprintf p "\n")
    (fprintf p "\n")
    (fprintf p "Setting design object,expecting nil, found to be: ")
   (pprint (axlSetParam dsn) p)
    (fprintf p "\n")
    (fprintf p "Returned nil as height and width are zero")
    (fprintf p "\n")
    (fprintf p "Retrieving design object, found to be: ")
    (pprint (setq dsn (axlGetParam "paramDesign")) p)
    (fprintf p "\n")
    (pprint dsn->?? p)
    (fprintf p "\n")
   ) ; defun test_design4

  (defun test_design5 (p)
    (pprint (setq dsn (axlGetParam "paramDesign")) p)
    (fprintf p "\n")
    (pprint dsn->?? p)
    (fprintf p "\n")
    (fprintf p "Setting width to: ")
   (pprint (dsn->width=15000) p)
    (fprintf p "\n")
    (fprintf p "Found width to be: ")
   (pprint dsn->width p)
    (fprintf p "\n")
    (fprintf p "Setting height to: ")
   (pprint (dsn->height=11000) p)
    (fprintf p "\n")
    (fprintf p "Found height to be: ")
   (pprint dsn->height p)
    (fprintf p "\n")
    (pprint dsn->?? p)
    (fprintf p "\n")
    (fprintf p "\n")
    (fprintf p "Setting design object, found to be: ")
   (pprint (axlSetParam dsn) p)
    (fprintf p "\n")
    (fprintf p "Retrieving design object, found to be: ")
    (pprint (setq dsn (axlGetParam "paramDesign")) p)
    (fprintf p "\n")
    (pprint dsn->?? p)
    (fprintf p "\n")
   ) ; defun test_design5

  (defun test_design6 (p)
    (pprint (setq dsn (axlGetParam "paramDesign")) p)
    (fprintf p "\n")
    (pprint dsn->?? p)
    (fprintf p "\n")
    (fprintf p "Setting accuracy to: ")
    (pprint (putprop dsn 2 'accuracy) p)
    (fprintf p "\n")
    (fprintf p "Found accuracy to be: ")
    (pprint dsn->accuracy  p)
;    (pprint (putprop dsn 35.0 'width) p)
    (fprintf p "\n")
    (fprintf p "Setting width to: ")
   (pprint (dsn->width=10000) p)
    (fprintf p "\n")
    (fprintf p "Found width to be: ")
   (pprint dsn->width p)
    (fprintf p "\n")
    (fprintf p "Setting units to: ")
   (pprint (dsn->units="microns") p)
    (fprintf p "\n")
    (fprintf p "Found units to be: ")
    (pprint dsn->units p)
    (fprintf p "\n")
    (fprintf p "Setting height to: ")
   (pprint (dsn->height=1000001.0) p)
    (fprintf p "\n")
    (fprintf p "Found height to be: ")
   (pprint dsn->height p)
    (fprintf p "\n")
    (fprintf p "Setting origin to: ")
    (pprint (putprop dsn '(10.0  10.0) 'xy) p)
    (fprintf p "\n")
    (fprintf p "Found origin to be: ")
   (pprint dsn->xy p)
    (fprintf p "\n")
    (pprint dsn->?? p)
    (fprintf p "\n")
    (fprintf p "\n")
    (fprintf p "Setting design object,expecting nil, found to be: ")
   (pprint (axlSetParam dsn) p)
    (fprintf p "\n")
    (fprintf p "Returned nil as height too big")
     (fprintf p "\n")
    (fprintf p "Retrieving design object, found to be: ")
    (pprint (setq dsn (axlGetParam "paramDesign")) p)
    (fprintf p "\n")
    (pprint dsn->?? p)
    (fprintf p "\n")
   ) ; defun test_design6

(defun axldesign_test ()
 (setq p outfile("bronze.txt", "a"))
 (setq _itemsperline 1)
 (fprintf p "\n\n*test_design:*******************************************\n\n")
 (test_design p)
 (fprintf p "\n\n*test_design1:\n\n")
 (test_design1 p)
 (fprintf p "\n\n*test_design2:\n\n")
 (test_design2 p)
 (fprintf p "\n\n*test_design3:\n\n")
 (test_design3 p)
 (fprintf p "\n\n*test_design4:\n\n")
 (test_design4 p)
 (fprintf p "\n\n*test_design5:\n\n")
 (test_design5 p)
 (fprintf p "\n\n*test_design6:\n\n")
 (test_design6 p)
 (close p)
) ; defun axldesign_test
