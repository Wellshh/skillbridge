;;;;;;;;;;;;;;;;;;;;;;;;;;;;;;;;;;;;;;;;;;;;;;;;;;;;;;;;;;;;;;;;;;;;;;;;;;;;;
 ; file.cc --
 ;
 ; Author --
 ;	Cadence Design Systems
 ;
 ; Function --
 ;
 ; Copyright, 1993, Cadence Design Systems, Inc.
 ; No part of this file may be reproduced, stored in a retrieval system,
 ; or transmitted in any form or by any means --- electronic, mechanical,
 ; photocopying, recording, or otherwise --- without prior written permission
 ; of Cadence Design Systems, Inc.
 ;
 ; WARRANTY:
 ; NONE. NONE. NONE.
 ; Use all material in this code at your own risk.  Cadence Design Systems
 ; makes no claims about any material in this archive.  These examples may
 ; not function or may only function in specific instances. We'd like to hear
 ; what you think of our approach to this, and how we can improve it.
 ;
 ; RESTRICTIONS:
 ; All software contained within this archive is in the public domain or
 ; the author has given us permission for redistribution.  Some packages
 ; have explicit copyrights and notices concerning their redistribution.
 ; Please carefully read all documentation with any package on this tape.
 ;;;;;;;;;;;;;;;;;;;;;;;;;;;;;;;;;;;;;;;;;;;;;;;;;;;;;;;;;;;;;;;;;;;;;;;;;;;;;

;; test_design  - test attribute access of Design Attrs
;find all Design Attrs
  ;    print out all attributes of Design Parameter type

  (defun test_design (p)
    (pprint (setq dsn (axlGetParam "paramDesign")) p)
    (fprintf p "\n")
    (fprintf p "\n")
    (pprint dsn->?? p)
    (fprintf p "\n")
    (fprintf p "Setting accuracy to: ")
    (pprint (putprop dsn 1 'accuracy) p)
    (fprintf p "\n")
    (fprintf p "Found accuracy to be: ")
    (pprint dsn->accuracy  p)
    (fprintf p "\n")
    (fprintf p "Setting width to: ")
   (pprint (dsn->width=10000) p)
    (fprintf p "\n")
    (fprintf p "Found width to be: ")
   (pprint dsn->width p)
    (fprintf p "\n")
    (pprint (dsn->units="microns") p)
    (fprintf p "\n")
    (fprintf p "Found units to be: ")
    (pprint dsn->units p)
    (fprintf p "\n")
    (fprintf p "Setting height to: ")
   (pprint (dsn->height=15000) p)
    (fprintf p "\n")
    (fprintf p "Found height to be: ")
   (pprint dsn->height p)
    (fprintf p "\n")
    (fprintf p "Setting objtype to: ")
   (pprint (dsn->objtype="Design") p)
    (fprintf p "\n")
    (fprintf p "Expecting nil, found objtype to be: ")
   (pprint dsn->objtype p)
    (fprintf p "\n")
    (pprint dsn->?? p)
    (fprintf p "\n")
    (fprintf p "\n")
    (fprintf p "Setting design object, found to be: ")
   (pprint (axlSetParam dsn) p)
    (fprintf p "\n")
    (fprintf p "Retrieving design object, found to be: ")
    (pprint (setq dsn (axlGetParam "paramDesign")) p)
    (fprintf p "\n")
    (pprint dsn->?? p)
    (fprintf p "\n")
   ) ; defun test_design

  (defun test_design1 (p)
    (pprint (setq dsn (axlGetParam "paramDesign")) p)
    (fprintf p "\n")
    (fprintf p "\n")
    (pprint dsn->?? p)
    (fprintf p "\n")
    (fprintf p "Setting accuracy to: ")
    (pprint (putprop dsn 5 'accuracy) p)
    (fprintf p "\n")
    (fprintf p "Found accuracy to be: ")
    (pprint dsn->accuracy  p)
    (fprintf p "\n")
    (fprintf p "Setting width to: ")
   (pprint (dsn->width=2.0) p)
    (fprintf p "\n")
    (fprintf p "Found width to be: ")
   (pprint dsn->width p)
    (fprintf p "\n")
    (fprintf p "Setting height to: ")
   (pprint (dsn->height=15000) p)
    (fprintf p "\n")
    (fprintf p "Found height to be: ")
   (pprint dsn->height p)
    (fprintf p "\n")
    (pprint (dsn->units="inches") p)
    (fprintf p "\n")
    (fprintf p "Found units to be: ")
    (pprint dsn->units p)
    (fprintf p "\n")
    (pprint dsn->?? p)
    (fprintf p "\n")
    (fprintf p "\n")
    (fprintf p "Setting design object, found to be: ")
   (pprint (axlSetParam dsn) p)
    (fprintf p "\n")
    (fprintf p "Retrieving design object, found to be: ")
    (pprint (setq dsn (axlGetParam "paramDesign")) p)
    (fprintf p "\n")
    (pprint dsn->?? p)
    (fprintf p "\n")
   ) ; defun test_design1

  (defun test_layer (p)
    (pprint (setq dsn (axlGetParam "paramLayerGroup:etch/paramLayer:top")) p)
    (fprintf p "\n")
    (fprintf p "\n")
    (pprint dsn->?? p)
    (fprintf p "\n")
    (fprintf p "Setting color to: ")
     (pprint (putprop dsn 8 'color) p)
    (fprintf p "\n")
    (fprintf p "Found color to be: ")
    (pprint dsn->color p)
    (fprintf p "\n")
    (fprintf p "Setting visibility to: ")
     (pprint (putprop dsn t 'visible) p)
    (fprintf p "\n")
    (fprintf p "Found visible to be: ")
    (pprint dsn->visible p)
    (fprintf p "\n")
    (fprintf p "Setting isEtch to: ")
    (pprint (dsn->isEtch=nil) p)
    (fprintf p "\n")
    (fprintf p "Expecting no change, found isEtch to be: ")
    (pprint dsn->isEtch p)
    (fprintf p "\n")
    (fprintf p "Setting Name to: ")
     (pprint (putprop dsn "BETTER" 'name) p)
    (fprintf p "\n")
    (fprintf p "(9304)Expecting no change, Found name to be: ")
    (pprint dsn->name p)
    (fprintf p "\n")
    (fprintf p "Setting objtype to: ")
   (pprint (dsn->objtype="Layer") p)
    (fprintf p "\n")
    (fprintf p "Expecting nil, found objtype to be: ")
   (pprint dsn->objtype p)
     (fprintf p "\n")
    (fprintf p "\n")
    (pprint dsn->?? p)
    (fprintf p "\n")
    (fprintf p "\n")
    (fprintf p "Setting layer object, found to be: ")
   (pprint (axlSetParam dsn) p)
    (fprintf p "\n")
    (fprintf p "Retrieving layer object, found to be: ")
    (pprint (setq dsn (axlGetParam "paramLayerGroup:etch/paramLayer:better")) p)
    (fprintf p "\n")
    (pprint dsn->?? p)
    (fprintf p "\n")
   ) ; defun test_layer

  (defun test_display (p)
    (pprint (setq dsn (axlGetParam "paramDisplay")) p)
    (fprintf p "\n")
    (fprintf p "\n")
    (pprint dsn->?? p)
    (fprintf p "\n")
    (fprintf p "Setting ActiveLayer to: ")
     (pprint (putprop dsn "PIN/PASTEMASK_TOP" 'activeLayer) p)
    (fprintf p "\n")
    (fprintf p "Found activeLayer to be: ")
    (pprint dsn->activeLayer p)
    (fprintf p "\n")
    (fprintf p "Setting AltLayer to: ")
     (pprint (putprop dsn "ETCH/THREE" 'altLayer) p)
    (fprintf p "\n")
    (fprintf p "Found AltLayer to be: ")
    (pprint dsn->altLayer p)
    (fprintf p "\n")
    (fprintf p "Setting snap to: ")
     (pprint (putprop dsn nil 'snap) p)
    (fprintf p "\n")
    (fprintf p "Found snap to be: ")
    (pprint dsn->snap p)
    (fprintf p "\n")
    (fprintf p "Setting autoFindFilter to: ")
    (pprint (dsn->autoFindFilter=nil) p)
    (fprintf p "\n")
    (fprintf p "Found autoFindFilter to be: ")
    (pprint dsn->autoFindfilter p)
    (fprintf p "\n")
    (fprintf p "Setting objtype to: ")
   (pprint (dsn->objtype="Display") p)
    (fprintf p "\n")
    (fprintf p "Expecting nil, found objtype to be: ")
   (pprint dsn->objtype p)
    (fprintf p "\n")
    (fprintf p "\n")
    (fprintf p "Setting layer object, found to be: ")
   (pprint (axlSetParam dsn) p)
    (fprintf p "\n")
    (fprintf p "Retrieving layer object, found to be: ")
    (pprint (setq dsn (axlGetParam "paramDisplay")) p)
    (pprint dsn->?? p)
    (fprintf p "\n")
   ) ; defun test_display

  (defun test_textblock (p)
    (pprint (setq dsn (axlGetParam "paramTextBlock:1")) p)
    (fprintf p "\n")
    (fprintf p "\n")
    (pprint dsn->?? p)
    (fprintf p "\n")
      (fprintf p "\n")
    (fprintf p "\n")
  (fprintf p "Setting photoWidth to: ")
     (pprint (putprop dsn -2.0 'photoWidth) p)
    (fprintf p "\n")
    (fprintf p "Found photoWidth to be: ")
    (pprint dsn->photoWidth p)
    (fprintf p "\n")
  (fprintf p "Setting Width to: ")
     (pprint (putprop dsn -2.0 'width) p)
    (fprintf p "\n")
    (fprintf p "Found Width to be: ")
    (pprint dsn->width p)
    (fprintf p "\n")
    (fprintf p "Setting Name to: ")
     (pprint (putprop dsn "-1" 'name) p)
    (fprintf p "\n")
    (fprintf p "Expecting no change, found name to be: ")
    (pprint dsn->name p)
    (fprintf p "\n")
    (fprintf p "Setting objtype to: ")
   (pprint (dsn->objtype="TextBlock") p)
    (fprintf p "\n")
     (fprintf p "Expecting nil, found objtype to be: ")
   (pprint dsn->objtype p)
    (fprintf p "\n")
    (fprintf p "\n")
    (fprintf p "Setting textblock object, found to be: ")
   (pprint (axlSetParam dsn) p)
    (fprintf p "\n")
    (fprintf p "Retrieving textblock object, found to be: ")
    (pprint (setq dsn (axlGetParam "paramTextBlock:1")) p)
    (pprint dsn->?? p)
    (fprintf p "\n")
  ) ; defun test_textblock

 (defun test_textblock1 (p)
    (pprint (setq dsn (axlGetParam "paramTextBlock:1")) p)
    (fprintf p "\n")
    (fprintf p "\n")
    (pprint dsn->?? p)
    (fprintf p "\n")
      (fprintf p "\n")
    (fprintf p "\n")
  (fprintf p "Setting photoWidth to: ")
     (pprint (putprop dsn 5.0 'photoWidth) p)
    (fprintf p "\n")
    (fprintf p "Found photoWidth to be: ")
    (pprint dsn->photoWidth p)
    (fprintf p "\n")
  (fprintf p "Setting Width to: ")
     (pprint (putprop dsn 3.0 'width) p)
    (fprintf p "\n")
    (fprintf p "Found Width to be: ")
    (pprint dsn->width p)
    (fprintf p "\n")
    (fprintf p "\n")
    (fprintf p "Setting textblock object, found to be: ")
   (pprint (axlSetParam dsn) p)
    (fprintf p "\n")
    (fprintf p "Retrieving textblock object, found to be: ")
    (pprint (setq dsn (axlGetParam "paramTextBlock:1")) p)
    (pprint dsn->?? p)
    (fprintf p "\n")
  ) ; defun test_textblock

  (defun test_textblockgroup (p)
    (pprint (setq dsn (axlGetParam "paramTextGroup")) p)
    (fprintf p "\n")
    (fprintf p "\n")
    (pprint dsn->?? p)
    (fprintf p "\n")
    (fprintf p "Setting NChildren to: ")
     (pprint (putprop dsn "15" 'nChildren) p)
    (fprintf p "\n")
    (fprintf p "Expecting no change, found nChildren to be: ")
    (pprint dsn->nChildren p)
    (fprintf p "\n")
    (fprintf p "Setting objtype to: ")
   (pprint (dsn->objtype="TextGroup") p)
    (fprintf p "\n")
     (fprintf p "Expecting nil, found objtype to be: ")
   (pprint dsn->objtype p)
    (fprintf p "\n")
  ) ; defun test_textblockgroup

  (defun test_layergroup (p)
    (pprint (setq dsn (axlGetParam "paramLayerGroup:PIN")) p)
    (fprintf p "\n")
    (fprintf p "\n")
    (pprint dsn->?? p)
    (fprintf p "\n")
    (fprintf p "Setting NChildren to: ")
     (pprint (putprop dsn "15" 'nChildren) p)
    (fprintf p "\n")
    (fprintf p "Expecting no change, found nChildren to be: ")
    (pprint dsn->nChildren p)
    (fprintf p "\n")
    (fprintf p "Setting objtype to: ")
   (pprint (dsn->objtype="LayerGroup") p)
    (fprintf p "\n")
   (fprintf p "Expecting nil, found objtype to be: ")
   (pprint dsn->objtype p)
    (fprintf p "\n")
 ) ; defun test_layergroup

  (defun test_layergroup1 (p)
    (pprint (setq lg (axlGetParam "paramLayerGroup:via class")) p)
    (fprintf p "\n")
    (fprintf p "Retrieving the same attr twice- objType:\n")
    (pprint lg->objType p)
    (fprintf p "\n")
    (pprint lg->objType p)
    (fprintf p "\n")
   ) ; defun test_layergroup1

(defun test_general (p)
   (let (x y z)
      (setq x (axlGetParam "paramDesign"))
	; test the eval function
	(fprintf p "Eval of x: %s\n", (eval x))
	; test the eq function
	(setq y (axlGetParam "paramDesign"))
	(fprintf p "Eq x y?: ")
	(cond ((equal x y) (fprintf p "t\n")) (t (fprintf p "nil\n")))
        (setq z (axlGetParam "paramDisplay"))
	(fprintf p "Eq x z?: ")
	(cond ((equal x z) (fprintf p "t\n")) (t (fprintf p "nil\n")))
	; test the singlequestion attr retrieval
	(pprint x->? p)
	(fprintf p "\n")
	; test illegal attr retrieval
	(fprintf p " retrieving illegal attr, dummy; expecting nil: ")
	(pprint x->dummy p)
   ) ; let
) ; test_general

(defun axldesign_test ()
 (setq p outfile("bronze.txt", "w"))
 (setq _itemsperline 1)
 (fprintf p "\n\ntest_layer:\n\n")
 (test_layer p)
 (fprintf p "\n\ntest_textblock:\n\n")
 (test_textblock p)
 (test_textblock1 p)
 (fprintf p "\n\ntest_design:\n\n")
 (test_design p)
 (test_design1 p)
 (fprintf p "\n\ntest_display:\n\n")
 (test_display p)
 (fprintf p "\n\ntest_textblockgroup:\n\n")
 (test_textblockgroup p)
 (fprintf p "\n\ntest_layergroup:\n\n")
 (test_layergroup p)
 (close p)
 ) ; defun axldesign_test

(defun my_fail_test1 ()
	(printf "test_design, expecting nil: ")
	(pprint (axlGetParam "design"))
	(printf "\n")
) ; my_fail_test1

(defun my_fail_test2 ()
	(printf "test_layer, expecting nil: ")
	(pprint (axlGetParam "paramtextblock"))
	(printf "\n")
) ; my_fail_test2

(defun my_fail_test3 ()
	(printf "test_layer, expecting nil: ")
	(pprint (axlGetParam "paramLayerGroup:VIA CLASS/paramLayer:VIA"))
	(printf "\n")
) ; my_fail_test3

(defun my_fail_test4 ()
	(printf "test_layer, expecting nil: ")
	(pprint (axlGetParam ""))
	(printf "\n")
) ; my_fail_test4

(defun my_fail_test5 ()
	(printf "test_layer, expecting nil: ")
	(pprint (axlGetParam "paramLayerGroup:VIA_PIN"))
	(printf "\n")
) ; my_fail_test5

(defun my_fail_test6 ()
	(printf "test_layer, expecting nil: ")
	(pprint (axlGetParam "paramLayerGroup:VIA_PIN/paramLayer:TOP"))
	(printf "\n")
) ; my_fail_test6
