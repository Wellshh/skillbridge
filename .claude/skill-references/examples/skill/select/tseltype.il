;;;;;;;;;;;;;;;;;;;;;;;;;;;;;;;;;;;;;;;;;;;;;;;;;;;;;;;;;;;;;;;;;;;;;;;;;;;;;
 ; file.cc --
 ;
 ; Author --
 ;	Cadence Design Systems
 ;
 ; Function --
 ;
 ; Copyright, 1993, Cadence Design Systems, Inc.
 ; No part of this file may be reproduced, stored in a retrieval system,
 ; or transmitted in any form or by any means --- electronic, mechanical,
 ; photocopying, recording, or otherwise --- without prior written permission
 ; of Cadence Design Systems, Inc.
 ;
 ; WARRANTY:
 ; NONE. NONE. NONE.
 ; Use all material in this code at your own risk.  Cadence Design Systems
 ; makes no claims about any material in this archive.  These examples may
 ; not function or may only function in specific instances. We'd like to hear
 ; what you think of our approach to this, and how we can improve it.
 ;
 ; RESTRICTIONS:
 ; All software contained within this archive is in the public domain or
 ; the author has given us permission for redistribution.  Some packages
 ; have explicit copyrights and notices concerning their redistribution.
 ; Please carefully read all documentation with any package on this tape.
 ;;;;;;;;;;;;;;;;;;;;;;;;;;;;;;;;;;;;;;;;;;;;;;;;;;;;;;;;;;;;;;;;;;;;;;;;;;;;;

;; tselTestAllTypes - Crosscheck that correct object types are selected
(defun tselTestAllTypes ()
    (let ((testPass t))

	(foreach objTypeData (tselGetObjectTypeData)
	    (when (null (tselObjTypeTest objTypeData))
		(setq testPass nil)))

	(tselEchoResults "Selset Type Crosscheck Test" testPass)))

; tselObjTypeTest - crosscheck object type for given type
(defun tselObjTypeTest (objTypeData "l")
    (let (objList (testPass t))
	(cond
	    ((null (setq objList (findAllOfType (car objTypeData))))
		(printf "tselObjTypeTest: No \"%s\" to select\n"
			(car objTypeData)))

	    ((null (tselTestObjType "tselObjTypeTest" objList objTypeData))
		nil)

	    (t (setq testPass t)))

	testPass))
